* RING_OSC -- LVS ソースネットリスト（設計意図側）
* scripts/pnr/mkringoscnet.py が生成。手で編集しないこと。
*
*   回路図 : TR-1um_Async_I2C/ring_osc/RING_OSC.sch / INV3D.sch
*   セル   : lef/simulation/*.spice（INV3D だけ回路図から直接）
*   FILL2 の個数だけ lef/RING_OSC.gds から数えた
*
* 1 リング 95 段 + AND 1 段 = 96 段の奇数閉ループが 2 本。
* 速い方は INV_X1、遅い方は INV3D（同じ 2T だがレイアウトが違う）。
* ENB=0 で FB/FD が 0 に固定されて止まり、ENB=1 で発振する。
* TAP2 はデバイスを持たないので出していない。

.subckt INV_X1 A Y vdd vss
MP0 Y A vdd vdd PMOS W=10.2u L=1.0u
MN0 Y A vss vss NMOS W=3.4u L=1.0u
.ends INV_X1
.subckt AND2_X1 Y A B vdd vss
MP0 n0 A vdd vdd PMOS W=10.2u L=1.0u
MP1 n0 B vdd vdd PMOS W=10.2u L=1.0u
MN0 s1 A vss vss NMOS W=3.4u L=1.0u
MN1 n0 B s1 vss NMOS W=3.4u L=1.0u
MP2 Y n0 vdd vdd PMOS W=10.2u L=1.0u
MN2 Y n0 vss vss NMOS W=3.4u L=1.0u
.ends AND2_X1
.subckt FILL2  vdd vss
MP0 vdd vss vdd vdd PMOS W=15.8u L=3.2u
MN0 vss vdd vss vss NMOS W=13.1u L=3.2u
.ends FILL2

.subckt INV3D A Y gnd vdd
MP0 Y A vdd vdd PMOS W=10.2u L=1.0u
MN0 Y A gnd gnd NMOS W=3.4u L=1.0u
.ends INV3D

.subckt RING_OSC ENB OUT OUTD VDD VSS
* --- 速いリング（INV_X1 x 95）---
xr0 FB R0 VDD VSS INV_X1
xr1 R0 R1 VDD VSS INV_X1
xr2 R1 R2 VDD VSS INV_X1
xr3 R2 R3 VDD VSS INV_X1
xr4 R3 R4 VDD VSS INV_X1
xr5 R4 R5 VDD VSS INV_X1
xr6 R5 R6 VDD VSS INV_X1
xr7 R6 R7 VDD VSS INV_X1
xr8 R7 R8 VDD VSS INV_X1
xr9 R8 R9 VDD VSS INV_X1
xr10 R9 R10 VDD VSS INV_X1
xr11 R10 R11 VDD VSS INV_X1
xr12 R11 R12 VDD VSS INV_X1
xr13 R12 R13 VDD VSS INV_X1
xr14 R13 R14 VDD VSS INV_X1
xr15 R14 R15 VDD VSS INV_X1
xr16 R15 R16 VDD VSS INV_X1
xr17 R16 R17 VDD VSS INV_X1
xr18 R17 R18 VDD VSS INV_X1
xr19 R18 R19 VDD VSS INV_X1
xr20 R19 R20 VDD VSS INV_X1
xr21 R20 R21 VDD VSS INV_X1
xr22 R21 R22 VDD VSS INV_X1
xr23 R22 R23 VDD VSS INV_X1
xr24 R23 R24 VDD VSS INV_X1
xr25 R24 R25 VDD VSS INV_X1
xr26 R25 R26 VDD VSS INV_X1
xr27 R26 R27 VDD VSS INV_X1
xr28 R27 R28 VDD VSS INV_X1
xr29 R28 R29 VDD VSS INV_X1
xr30 R29 R30 VDD VSS INV_X1
xr31 R30 R31 VDD VSS INV_X1
xr32 R31 R32 VDD VSS INV_X1
xr33 R32 R33 VDD VSS INV_X1
xr34 R33 R34 VDD VSS INV_X1
xr35 R34 R35 VDD VSS INV_X1
xr36 R35 R36 VDD VSS INV_X1
xr37 R36 R37 VDD VSS INV_X1
xr38 R37 R38 VDD VSS INV_X1
xr39 R38 R39 VDD VSS INV_X1
xr40 R39 R40 VDD VSS INV_X1
xr41 R40 R41 VDD VSS INV_X1
xr42 R41 R42 VDD VSS INV_X1
xr43 R42 R43 VDD VSS INV_X1
xr44 R43 R44 VDD VSS INV_X1
xr45 R44 R45 VDD VSS INV_X1
xr46 R45 R46 VDD VSS INV_X1
xr47 R46 R47 VDD VSS INV_X1
xr48 R47 R48 VDD VSS INV_X1
xr49 R48 R49 VDD VSS INV_X1
xr50 R49 R50 VDD VSS INV_X1
xr51 R50 R51 VDD VSS INV_X1
xr52 R51 R52 VDD VSS INV_X1
xr53 R52 R53 VDD VSS INV_X1
xr54 R53 R54 VDD VSS INV_X1
xr55 R54 R55 VDD VSS INV_X1
xr56 R55 R56 VDD VSS INV_X1
xr57 R56 R57 VDD VSS INV_X1
xr58 R57 R58 VDD VSS INV_X1
xr59 R58 R59 VDD VSS INV_X1
xr60 R59 R60 VDD VSS INV_X1
xr61 R60 R61 VDD VSS INV_X1
xr62 R61 R62 VDD VSS INV_X1
xr63 R62 R63 VDD VSS INV_X1
xr64 R63 R64 VDD VSS INV_X1
xr65 R64 R65 VDD VSS INV_X1
xr66 R65 R66 VDD VSS INV_X1
xr67 R66 R67 VDD VSS INV_X1
xr68 R67 R68 VDD VSS INV_X1
xr69 R68 R69 VDD VSS INV_X1
xr70 R69 R70 VDD VSS INV_X1
xr71 R70 R71 VDD VSS INV_X1
xr72 R71 R72 VDD VSS INV_X1
xr73 R72 R73 VDD VSS INV_X1
xr74 R73 R74 VDD VSS INV_X1
xr75 R74 R75 VDD VSS INV_X1
xr76 R75 R76 VDD VSS INV_X1
xr77 R76 R77 VDD VSS INV_X1
xr78 R77 R78 VDD VSS INV_X1
xr79 R78 R79 VDD VSS INV_X1
xr80 R79 R80 VDD VSS INV_X1
xr81 R80 R81 VDD VSS INV_X1
xr82 R81 R82 VDD VSS INV_X1
xr83 R82 R83 VDD VSS INV_X1
xr84 R83 R84 VDD VSS INV_X1
xr85 R84 R85 VDD VSS INV_X1
xr86 R85 R86 VDD VSS INV_X1
xr87 R86 R87 VDD VSS INV_X1
xr88 R87 R88 VDD VSS INV_X1
xr89 R88 R89 VDD VSS INV_X1
xr90 R89 R90 VDD VSS INV_X1
xr91 R90 R91 VDD VSS INV_X1
xr92 R91 R92 VDD VSS INV_X1
xr93 R92 R93 VDD VSS INV_X1
xr94 R93 R94 VDD VSS INV_X1
xand_r FB R94 ENB VDD VSS AND2_X1
xbuf_r FB OUT VDD VSS INV_X1

* --- 遅いリング（INV3D x 95）---
xd0 FD D0 VSS VDD INV3D
xd1 D0 D1 VSS VDD INV3D
xd2 D1 D2 VSS VDD INV3D
xd3 D2 D3 VSS VDD INV3D
xd4 D3 D4 VSS VDD INV3D
xd5 D4 D5 VSS VDD INV3D
xd6 D5 D6 VSS VDD INV3D
xd7 D6 D7 VSS VDD INV3D
xd8 D7 D8 VSS VDD INV3D
xd9 D8 D9 VSS VDD INV3D
xd10 D9 D10 VSS VDD INV3D
xd11 D10 D11 VSS VDD INV3D
xd12 D11 D12 VSS VDD INV3D
xd13 D12 D13 VSS VDD INV3D
xd14 D13 D14 VSS VDD INV3D
xd15 D14 D15 VSS VDD INV3D
xd16 D15 D16 VSS VDD INV3D
xd17 D16 D17 VSS VDD INV3D
xd18 D17 D18 VSS VDD INV3D
xd19 D18 D19 VSS VDD INV3D
xd20 D19 D20 VSS VDD INV3D
xd21 D20 D21 VSS VDD INV3D
xd22 D21 D22 VSS VDD INV3D
xd23 D22 D23 VSS VDD INV3D
xd24 D23 D24 VSS VDD INV3D
xd25 D24 D25 VSS VDD INV3D
xd26 D25 D26 VSS VDD INV3D
xd27 D26 D27 VSS VDD INV3D
xd28 D27 D28 VSS VDD INV3D
xd29 D28 D29 VSS VDD INV3D
xd30 D29 D30 VSS VDD INV3D
xd31 D30 D31 VSS VDD INV3D
xd32 D31 D32 VSS VDD INV3D
xd33 D32 D33 VSS VDD INV3D
xd34 D33 D34 VSS VDD INV3D
xd35 D34 D35 VSS VDD INV3D
xd36 D35 D36 VSS VDD INV3D
xd37 D36 D37 VSS VDD INV3D
xd38 D37 D38 VSS VDD INV3D
xd39 D38 D39 VSS VDD INV3D
xd40 D39 D40 VSS VDD INV3D
xd41 D40 D41 VSS VDD INV3D
xd42 D41 D42 VSS VDD INV3D
xd43 D42 D43 VSS VDD INV3D
xd44 D43 D44 VSS VDD INV3D
xd45 D44 D45 VSS VDD INV3D
xd46 D45 D46 VSS VDD INV3D
xd47 D46 D47 VSS VDD INV3D
xd48 D47 D48 VSS VDD INV3D
xd49 D48 D49 VSS VDD INV3D
xd50 D49 D50 VSS VDD INV3D
xd51 D50 D51 VSS VDD INV3D
xd52 D51 D52 VSS VDD INV3D
xd53 D52 D53 VSS VDD INV3D
xd54 D53 D54 VSS VDD INV3D
xd55 D54 D55 VSS VDD INV3D
xd56 D55 D56 VSS VDD INV3D
xd57 D56 D57 VSS VDD INV3D
xd58 D57 D58 VSS VDD INV3D
xd59 D58 D59 VSS VDD INV3D
xd60 D59 D60 VSS VDD INV3D
xd61 D60 D61 VSS VDD INV3D
xd62 D61 D62 VSS VDD INV3D
xd63 D62 D63 VSS VDD INV3D
xd64 D63 D64 VSS VDD INV3D
xd65 D64 D65 VSS VDD INV3D
xd66 D65 D66 VSS VDD INV3D
xd67 D66 D67 VSS VDD INV3D
xd68 D67 D68 VSS VDD INV3D
xd69 D68 D69 VSS VDD INV3D
xd70 D69 D70 VSS VDD INV3D
xd71 D70 D71 VSS VDD INV3D
xd72 D71 D72 VSS VDD INV3D
xd73 D72 D73 VSS VDD INV3D
xd74 D73 D74 VSS VDD INV3D
xd75 D74 D75 VSS VDD INV3D
xd76 D75 D76 VSS VDD INV3D
xd77 D76 D77 VSS VDD INV3D
xd78 D77 D78 VSS VDD INV3D
xd79 D78 D79 VSS VDD INV3D
xd80 D79 D80 VSS VDD INV3D
xd81 D80 D81 VSS VDD INV3D
xd82 D81 D82 VSS VDD INV3D
xd83 D82 D83 VSS VDD INV3D
xd84 D83 D84 VSS VDD INV3D
xd85 D84 D85 VSS VDD INV3D
xd86 D85 D86 VSS VDD INV3D
xd87 D86 D87 VSS VDD INV3D
xd88 D87 D88 VSS VDD INV3D
xd89 D88 D89 VSS VDD INV3D
xd90 D89 D90 VSS VDD INV3D
xd91 D90 D91 VSS VDD INV3D
xd92 D91 D92 VSS VDD INV3D
xd93 D92 D93 VSS VDD INV3D
xd94 D93 D94 VSS VDD INV3D
xand_d FD D94 ENB VDD VSS AND2_X1
xbuf_d FD OUTD VDD VSS INV_X1

* --- デキャップ（FILL2 x 206）---
xf0 VDD VSS FILL2
xf1 VDD VSS FILL2
xf2 VDD VSS FILL2
xf3 VDD VSS FILL2
xf4 VDD VSS FILL2
xf5 VDD VSS FILL2
xf6 VDD VSS FILL2
xf7 VDD VSS FILL2
xf8 VDD VSS FILL2
xf9 VDD VSS FILL2
xf10 VDD VSS FILL2
xf11 VDD VSS FILL2
xf12 VDD VSS FILL2
xf13 VDD VSS FILL2
xf14 VDD VSS FILL2
xf15 VDD VSS FILL2
xf16 VDD VSS FILL2
xf17 VDD VSS FILL2
xf18 VDD VSS FILL2
xf19 VDD VSS FILL2
xf20 VDD VSS FILL2
xf21 VDD VSS FILL2
xf22 VDD VSS FILL2
xf23 VDD VSS FILL2
xf24 VDD VSS FILL2
xf25 VDD VSS FILL2
xf26 VDD VSS FILL2
xf27 VDD VSS FILL2
xf28 VDD VSS FILL2
xf29 VDD VSS FILL2
xf30 VDD VSS FILL2
xf31 VDD VSS FILL2
xf32 VDD VSS FILL2
xf33 VDD VSS FILL2
xf34 VDD VSS FILL2
xf35 VDD VSS FILL2
xf36 VDD VSS FILL2
xf37 VDD VSS FILL2
xf38 VDD VSS FILL2
xf39 VDD VSS FILL2
xf40 VDD VSS FILL2
xf41 VDD VSS FILL2
xf42 VDD VSS FILL2
xf43 VDD VSS FILL2
xf44 VDD VSS FILL2
xf45 VDD VSS FILL2
xf46 VDD VSS FILL2
xf47 VDD VSS FILL2
xf48 VDD VSS FILL2
xf49 VDD VSS FILL2
xf50 VDD VSS FILL2
xf51 VDD VSS FILL2
xf52 VDD VSS FILL2
xf53 VDD VSS FILL2
xf54 VDD VSS FILL2
xf55 VDD VSS FILL2
xf56 VDD VSS FILL2
xf57 VDD VSS FILL2
xf58 VDD VSS FILL2
xf59 VDD VSS FILL2
xf60 VDD VSS FILL2
xf61 VDD VSS FILL2
xf62 VDD VSS FILL2
xf63 VDD VSS FILL2
xf64 VDD VSS FILL2
xf65 VDD VSS FILL2
xf66 VDD VSS FILL2
xf67 VDD VSS FILL2
xf68 VDD VSS FILL2
xf69 VDD VSS FILL2
xf70 VDD VSS FILL2
xf71 VDD VSS FILL2
xf72 VDD VSS FILL2
xf73 VDD VSS FILL2
xf74 VDD VSS FILL2
xf75 VDD VSS FILL2
xf76 VDD VSS FILL2
xf77 VDD VSS FILL2
xf78 VDD VSS FILL2
xf79 VDD VSS FILL2
xf80 VDD VSS FILL2
xf81 VDD VSS FILL2
xf82 VDD VSS FILL2
xf83 VDD VSS FILL2
xf84 VDD VSS FILL2
xf85 VDD VSS FILL2
xf86 VDD VSS FILL2
xf87 VDD VSS FILL2
xf88 VDD VSS FILL2
xf89 VDD VSS FILL2
xf90 VDD VSS FILL2
xf91 VDD VSS FILL2
xf92 VDD VSS FILL2
xf93 VDD VSS FILL2
xf94 VDD VSS FILL2
xf95 VDD VSS FILL2
xf96 VDD VSS FILL2
xf97 VDD VSS FILL2
xf98 VDD VSS FILL2
xf99 VDD VSS FILL2
xf100 VDD VSS FILL2
xf101 VDD VSS FILL2
xf102 VDD VSS FILL2
xf103 VDD VSS FILL2
xf104 VDD VSS FILL2
xf105 VDD VSS FILL2
xf106 VDD VSS FILL2
xf107 VDD VSS FILL2
xf108 VDD VSS FILL2
xf109 VDD VSS FILL2
xf110 VDD VSS FILL2
xf111 VDD VSS FILL2
xf112 VDD VSS FILL2
xf113 VDD VSS FILL2
xf114 VDD VSS FILL2
xf115 VDD VSS FILL2
xf116 VDD VSS FILL2
xf117 VDD VSS FILL2
xf118 VDD VSS FILL2
xf119 VDD VSS FILL2
xf120 VDD VSS FILL2
xf121 VDD VSS FILL2
xf122 VDD VSS FILL2
xf123 VDD VSS FILL2
xf124 VDD VSS FILL2
xf125 VDD VSS FILL2
xf126 VDD VSS FILL2
xf127 VDD VSS FILL2
xf128 VDD VSS FILL2
xf129 VDD VSS FILL2
xf130 VDD VSS FILL2
xf131 VDD VSS FILL2
xf132 VDD VSS FILL2
xf133 VDD VSS FILL2
xf134 VDD VSS FILL2
xf135 VDD VSS FILL2
xf136 VDD VSS FILL2
xf137 VDD VSS FILL2
xf138 VDD VSS FILL2
xf139 VDD VSS FILL2
xf140 VDD VSS FILL2
xf141 VDD VSS FILL2
xf142 VDD VSS FILL2
xf143 VDD VSS FILL2
xf144 VDD VSS FILL2
xf145 VDD VSS FILL2
xf146 VDD VSS FILL2
xf147 VDD VSS FILL2
xf148 VDD VSS FILL2
xf149 VDD VSS FILL2
xf150 VDD VSS FILL2
xf151 VDD VSS FILL2
xf152 VDD VSS FILL2
xf153 VDD VSS FILL2
xf154 VDD VSS FILL2
xf155 VDD VSS FILL2
xf156 VDD VSS FILL2
xf157 VDD VSS FILL2
xf158 VDD VSS FILL2
xf159 VDD VSS FILL2
xf160 VDD VSS FILL2
xf161 VDD VSS FILL2
xf162 VDD VSS FILL2
xf163 VDD VSS FILL2
xf164 VDD VSS FILL2
xf165 VDD VSS FILL2
xf166 VDD VSS FILL2
xf167 VDD VSS FILL2
xf168 VDD VSS FILL2
xf169 VDD VSS FILL2
xf170 VDD VSS FILL2
xf171 VDD VSS FILL2
xf172 VDD VSS FILL2
xf173 VDD VSS FILL2
xf174 VDD VSS FILL2
xf175 VDD VSS FILL2
xf176 VDD VSS FILL2
xf177 VDD VSS FILL2
xf178 VDD VSS FILL2
xf179 VDD VSS FILL2
xf180 VDD VSS FILL2
xf181 VDD VSS FILL2
xf182 VDD VSS FILL2
xf183 VDD VSS FILL2
xf184 VDD VSS FILL2
xf185 VDD VSS FILL2
xf186 VDD VSS FILL2
xf187 VDD VSS FILL2
xf188 VDD VSS FILL2
xf189 VDD VSS FILL2
xf190 VDD VSS FILL2
xf191 VDD VSS FILL2
xf192 VDD VSS FILL2
xf193 VDD VSS FILL2
xf194 VDD VSS FILL2
xf195 VDD VSS FILL2
xf196 VDD VSS FILL2
xf197 VDD VSS FILL2
xf198 VDD VSS FILL2
xf199 VDD VSS FILL2
xf200 VDD VSS FILL2
xf201 VDD VSS FILL2
xf202 VDD VSS FILL2
xf203 VDD VSS FILL2
xf204 VDD VSS FILL2
xf205 VDD VSS FILL2
.ends RING_OSC
