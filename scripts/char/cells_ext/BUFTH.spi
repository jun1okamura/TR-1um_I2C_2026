* Created by KLayout
*** My special header ***

* cell BUFTH
* pin A
* pin Y
* pin vss
* pin vdd
.SUBCKT BUFTH A Y vss vdd
* device instance $1 r0 *1 10.8,47.85 PMOS
XM1 vss n6 n7 vdd PMOS L=1u W=10.2u AS=21.93p AD=21.93p PS=23.9u PD=23.9u
* device instance $3 r0 *1 26,41.7 PMOS
XM3 vdd n6 Y vdd PMOS L=1u W=10.2u AS=28.56p AD=28.56p PS=26u PD=26u
* device instance $4 r0 *1 10.8,39.15 PMOS
XM4 n6 A n7 vdd PMOS L=1u W=5.1u AS=14.28p AD=7.65p PS=15.8u PD=8.1u
* device instance $5 r0 *1 14.8,39.15 PMOS
XM5 n7 A vdd vdd PMOS L=1u W=5.1u AS=7.65p AD=14.28p PS=8.1u PD=15.8u
* device instance $6 r0 *1 26,17.9 NMOS
XM6 vss n6 Y vss NMOS L=1u W=3.4u AS=9.52p AD=9.52p PS=12.4u PD=12.4u
* device instance $7 r0 *1 10.8,17.9 NMOS
XM7 n6 A n3 vss NMOS L=1u W=3.4u AS=9.52p AD=5.1p PS=12.4u PD=6.4u
* device instance $8 r0 *1 14.8,17.9 NMOS
XM8 n3 A vss vss NMOS L=1u W=3.4u AS=5.1p AD=9.52p PS=6.4u PD=12.4u
* device instance $9 r0 *1 10.8,10 NMOS
XM9 vdd n6 n3 vss NMOS L=1u W=6.8u AS=14.62p AD=14.62p PS=18.8u PD=18.8u
.ENDS BUFTH
