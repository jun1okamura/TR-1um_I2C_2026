* Created by KLayout
*** My special header ***

* cell OSS_FRAME_GIO
* pin HIZ1
* pin HIZ10
* pin HIZ11
* pin HIZ12
* pin HIZ13
* pin HIZ14
* pin HIZ15
* pin HIZ2
* pin HIZ3
* pin HIZ4
* pin HIZ5
* pin HIZ6
* pin HIZ7
* pin HIZ9
* pin OUT1
* pin OUT10
* pin OUT11
* pin OUT12
* pin OUT13
* pin OUT14
* pin OUT15
* pin OUT2
* pin OUT3
* pin OUT4
* pin OUT5
* pin OUT6
* pin OUT7
* pin OUT9
* pin P1
* pin P10
* pin P11
* pin P12
* pin P13
* pin P14
* pin P15
* pin P2
* pin P3
* pin P4
* pin P5
* pin P6
* pin P7
* pin P9
* pin VDD
* pin VSS
.SUBCKT OSS_FRAME_GIO HIZ1 HIZ10 HIZ11 HIZ12 HIZ13 HIZ14 HIZ15 HIZ2 HIZ3 HIZ4
+ HIZ5 HIZ6 HIZ7 HIZ9 OUT1 OUT10 OUT11 OUT12 OUT13 OUT14 OUT15 OUT2 OUT3 OUT4
+ OUT5 OUT6 OUT7 OUT9 P1 P10 P11 P12 P13 P14 P15 P2 P3 P4 P5 P6 P7 P9 VDD VSS
* cell instance $4 m45 *1 -1040,-600
X4 P6 VDD OUT6 HIZ6 VSS OSS_ESD_5V_DIO
* cell instance $5 m135 *1 1040,-200
X5 P12 VDD OUT12 HIZ12 VSS OSS_ESD_5V_DIO
* cell instance $6 m135 *1 1040,600
X6 P14 VDD OUT14 HIZ14 VSS OSS_ESD_5V_DIO
* cell instance $7 m90 *1 600,-1040
X7 P10 VDD OUT10 HIZ10 VSS OSS_ESD_5V_DIO
* cell instance $9 m45 *1 -1040,200
X9 P4 VDD OUT4 HIZ4 VSS OSS_ESD_5V_DIO
* cell instance $10 m0 *1 -600,1040
X10 P2 VDD OUT2 HIZ2 VSS OSS_ESD_5V_DIO
* cell instance $11 r270 *1 -1040,600
X11 P3 VDD OUT3 HIZ3 VSS OSS_ESD_5V_DIO
* cell instance $12 r270 *1 -1040,-200
X12 P5 VDD OUT5 HIZ5 VSS OSS_ESD_5V_DIO
* cell instance $13 r180 *1 600,1040
X13 P15 VDD OUT15 HIZ15 VSS OSS_ESD_5V_DIO
* cell instance $14 r180 *1 -200,1040
X14 P1 VDD OUT1 HIZ1 VSS OSS_ESD_5V_DIO
* cell instance $15 m0 *1 200,1040
X15 VDD VSS OSS_ESD_5V_VDD
* cell instance $16 r90 *1 1040,200
X16 P13 VDD OUT13 HIZ13 VSS OSS_ESD_5V_DIO
* cell instance $17 r90 *1 1040,-600
X17 P11 VDD OUT11 HIZ11 VSS OSS_ESD_5V_DIO
* cell instance $18 r0 *1 -600,-1040
X18 P7 VDD OUT7 HIZ7 VSS OSS_ESD_5V_DIO
* cell instance $19 r0 *1 200,-1040
X19 P9 VDD OUT9 HIZ9 VSS OSS_ESD_5V_DIO
* cell instance $20 m90 *1 -200,-1040
X20 VDD VSS OSS_ESD_5V_VSS
.ENDS OSS_FRAME_GIO

* cell OSS_ESD_5V_VDD
* pin PAD,VDD
* pin VSS
.SUBCKT OSS_ESD_5V_VDD PAD|VDD VSS
* cell instance $1 r90 *1 130,0
X1 PAD|VDD VSS OSS_NCH_ESD
* cell instance $2 r270 *1 -130,0
X2 VSS PAD|VDD OSS_PCH_ESD
.ENDS OSS_ESD_5V_VDD

* cell OSS_ESD_5V_VSS
* pin VDD
* pin PAD,VSS
.SUBCKT OSS_ESD_5V_VSS VDD PAD|VSS
* cell instance $1 r90 *1 -130,0
X1 PAD|VSS VDD OSS_PCH_ESD
* cell instance $2 r270 *1 130,0
X2 VDD PAD|VSS OSS_NCH_ESD
.ENDS OSS_ESD_5V_VSS

* cell OSS_ESD_5V_DIO
* pin PAD
* pin VDD
* pin OUT
* pin HIZ
* pin VSS
.SUBCKT OSS_ESD_5V_DIO PAD VDD OUT HIZ VSS
* cell instance $1 r90 *1 -130,0
X1 PAD VDD n8 OSS_PCH_DRV
* cell instance $2 r90 *1 130,0
X2 PAD n9 VSS OSS_NCH_DRV
* cell instance $5 m0 *1 0,107.8
X5 OUT HIZ VDD n8 n9 VSS OSS_DRV
.ENDS OSS_ESD_5V_DIO

* cell OSS_PCH_ESD
* pin PAD
* pin VDD
.SUBCKT OSS_PCH_ESD PAD VDD
* device instance $1 r0 *1 -65.5,0 PMOS
XM1 PAD VDD VDD VDD PMOS L=2u W=500u AS=3523.04p AD=3523.04p PS=689.36u
+ PD=689.36u
.ENDS OSS_PCH_ESD

* cell OSS_NCH_ESD
* pin PAD
* pin VSS
.SUBCKT OSS_NCH_ESD PAD VSS
* device instance $1 r0 *1 -65.5,0 NMOSE
XM1 PAD VSS VSS VSS NMOSE L=2u W=500u AS=3523.04p AD=3523.04p PS=689.36u
+ PD=689.36u
.ENDS OSS_NCH_ESD

* cell OSS_DRV
* pin OUT
* pin HIZ
* pin vdd
* pin
* pin
* pin GND,vss
.SUBCKT OSS_DRV OUT HIZ vdd n16 n17 GND|vss
* device instance $1 r0 *1 47.1,13.5 PMOS
XM1 vdd n13 n17 vdd PMOS L=1u W=19.4u AS=52.76p AD=54.32p PS=44.2u PD=50u
* device instance $2 r0 *1 -37.2,5.3 PMOS
XM2 n12 HIZ n14 vdd PMOS L=1u W=10.4u AS=29.12p AD=6.24p PS=26.4u PD=11.6u
* device instance $3 r0 *1 -37.2,7.5 PMOS
XM3 n14 n7 vdd vdd PMOS L=1u W=10.4u AS=6.24p AD=26p PS=11.6u PD=15.4u
* device instance $4 r0 *1 -37.2,13.5 PMOS
XM4 vdd n12 n16 vdd PMOS L=1u W=20.8u AS=55.12p AD=58.24p PS=41.8u PD=52.8u
* device instance $6 r0 *1 34.6,-0.5 PMOS
XM6 n6 HIZ vdd vdd PMOS L=1u W=5.2u AS=14.56p AD=7.8p PS=16u PD=8.2u
* device instance $7 r0 *1 34.6,3.5 PMOS
XM7 vdd n6 n13 vdd PMOS L=1u W=5.2u AS=7.8p AD=7.8p PS=8.2u PD=8.2u
* device instance $8 r0 *1 34.6,7.5 PMOS
XM8 n13 n7 vdd vdd PMOS L=1u W=5.2u AS=7.8p AD=13p PS=8.2u PD=10.2u
* device instance $10 r0 *1 -46.4,-0.5 PMOS
XM10 n7 OUT vdd vdd PMOS L=1u W=5.2u AS=14.56p AD=22.36p PS=16u PD=19u
* device instance $11 r0 *1 -13.3,-0.5 NMOS
XM11 n7 OUT GND|vss GND|vss NMOS L=1u W=3.4u AS=9.52p AD=5.1p PS=12.4u PD=6.4u
* device instance $12 r0 *1 -13.3,3.5 NMOS
XM12 GND|vss HIZ n12 GND|vss NMOS L=1u W=3.4u AS=5.1p AD=5.1p PS=6.4u PD=6.4u
* device instance $13 r0 *1 -13.3,7.5 NMOS
XM13 n12 n7 GND|vss GND|vss NMOS L=1u W=3.4u AS=5.1p AD=8.5p PS=6.4u PD=8.4u
* device instance $14 r0 *1 -13.3,13.5 NMOS
XM14 GND|vss n12 n16 GND|vss NMOS L=1u W=6.8u AS=18.02p AD=19.04p PS=20.8u
+ PD=24.8u
* device instance $16 r0 *1 13.3,5.3 NMOS
XM16 n13 n6 n15 GND|vss NMOS L=1u W=3.4u AS=9.52p AD=2.04p PS=12.4u PD=4.6u
* device instance $17 r0 *1 13.3,7.5 NMOS
XM17 n15 n7 GND|vss GND|vss NMOS L=1u W=3.4u AS=2.04p AD=8.5p PS=4.6u PD=8.4u
* device instance $18 r0 *1 13.3,13.5 NMOS
XM18 GND|vss n13 n17 GND|vss NMOS L=1u W=6.8u AS=18.02p AD=19.04p PS=20.8u
+ PD=24.8u
* device instance $20 r0 *1 8.5,-0.5 NMOS
XM20 n6 HIZ GND|vss GND|vss NMOS L=1u W=3.4u AS=9.52p AD=9.52p PS=12.4u
+ PD=12.4u
* device instance $21 r0 *1 -13.2,-8.4 DN
D_21 GND|vss OUT DN A=12.96p P=14.4u
* device instance $22 r0 *1 8.6,-8.4 DN
D_22 GND|vss HIZ DN A=12.96p P=14.4u
.ENDS OSS_DRV

* cell OSS_PCH_DRV
* pin PAD
* pin VDD
* pin
.SUBCKT OSS_PCH_DRV PAD VDD n3
* device instance $1 r0 *1 -65.5,0 PMOS
XM1 PAD VDD VDD VDD PMOS L=2u W=200u AS=1573.04p AD=1300p PS=311.36u PD=252u
* device instance $5 r0 *1 -5.5,0 PMOS
XM5 PAD n3 VDD VDD PMOS L=2u W=300u AS=1950p AD=2223.04p PS=378u PD=437.36u
.ENDS OSS_PCH_DRV

* cell OSS_NCH_DRV
* pin PAD
* pin
* pin VSS
.SUBCKT OSS_NCH_DRV PAD n14 VSS
* device instance $1 r0 *1 -65.5,0 NMOSE
XM1 PAD VSS VSS VSS NMOSE L=2u W=350u AS=2648.04p AD=2175p PS=504.36u PD=437u
* device instance $8 r0 *1 35.5,0 NMOSE
XM8 VSS n14 PAD VSS NMOSE L=2u W=150u AS=875p AD=1348.04p PS=185u PD=252.36u
.ENDS OSS_NCH_DRV
