* TR-1um ADDBUF — KLayout 抽出 (scripts/klayout_extract.py)

* cell ADDBUF
* pin A0
* pin A0_PIN
* pin A1
* pin A1_PIN
* pin A2
* pin A2_PIN
* pin A3
* pin A3_PIN
* pin AB0
* pin AB1
* pin AB2
* pin AB3
* pin WEB
* pin WEB_PIN
* pin vss
* pin vdd
.SUBCKT ADDBUF A0 A0_PIN A1 A1_PIN A2 A2_PIN A3 A3_PIN AB0 AB1 AB2 AB3 WEB
+ WEB_PIN vss vdd
* device instance $1 r0 *1 28,41.7 PMOS
XM1 vdd n6 WEB vdd PMOS L=1U W=10.2U AS=28.56P AD=15.3P PS=26U PD=13.2U
* device instance $2 r0 *1 32,41.7 PMOS
XM2 n6 WEB_PIN vdd vdd PMOS L=1U W=10.2U AS=15.3P AD=28.56P PS=13.2U PD=26U
* device instance $3 r0 *1 -20,41.7 PMOS
XM3 vdd AB3 A3 vdd PMOS L=1U W=10.2U AS=28.56P AD=15.3P PS=26U PD=13.2U
* device instance $4 r0 *1 -16,41.7 PMOS
XM4 AB3 A3_PIN vdd vdd PMOS L=1U W=10.2U AS=15.3P AD=28.56P PS=13.2U PD=26U
* device instance $5 r0 *1 4,41.7 PMOS
XM5 vdd A1_PIN AB1 vdd PMOS L=1U W=10.2U AS=28.56P AD=15.3P PS=26U PD=13.2U
* device instance $6 r0 *1 8,41.7 PMOS
XM6 A1 AB1 vdd vdd PMOS L=1U W=10.2U AS=15.3P AD=28.56P PS=13.2U PD=26U
* device instance $7 r0 *1 -8,41.7 PMOS
XM7 vdd AB2 A2 vdd PMOS L=1U W=10.2U AS=28.56P AD=15.3P PS=26U PD=13.2U
* device instance $8 r0 *1 -4,41.7 PMOS
XM8 AB2 A2_PIN vdd vdd PMOS L=1U W=10.2U AS=15.3P AD=28.56P PS=13.2U PD=26U
* device instance $9 r0 *1 16,41.7 PMOS
XM9 vdd A0_PIN AB0 vdd PMOS L=1U W=10.2U AS=28.56P AD=15.3P PS=26U PD=13.2U
* device instance $10 r0 *1 20,41.7 PMOS
XM10 A0 AB0 vdd vdd PMOS L=1U W=10.2U AS=15.3P AD=28.56P PS=13.2U PD=26U
* device instance $11 r0 *1 28,17.9 NMOS
XM11 vss n6 WEB vss NMOS L=1U W=3.4U AS=9.52P AD=5.1P PS=12.4U PD=6.4U
* device instance $12 r0 *1 32,17.9 NMOS
XM12 n6 WEB_PIN vss vss NMOS L=1U W=3.4U AS=5.1P AD=9.52P PS=6.4U PD=12.4U
* device instance $13 r0 *1 16,17.9 NMOS
XM13 vss A0_PIN AB0 vss NMOS L=1U W=3.4U AS=9.52P AD=5.1P PS=12.4U PD=6.4U
* device instance $14 r0 *1 20,17.9 NMOS
XM14 A0 AB0 vss vss NMOS L=1U W=3.4U AS=5.1P AD=9.52P PS=6.4U PD=12.4U
* device instance $15 r0 *1 4,17.9 NMOS
XM15 vss A1_PIN AB1 vss NMOS L=1U W=3.4U AS=9.52P AD=5.1P PS=12.4U PD=6.4U
* device instance $16 r0 *1 8,17.9 NMOS
XM16 A1 AB1 vss vss NMOS L=1U W=3.4U AS=5.1P AD=9.52P PS=6.4U PD=12.4U
* device instance $17 r0 *1 -8,17.9 NMOS
XM17 vss AB2 A2 vss NMOS L=1U W=3.4U AS=9.52P AD=5.1P PS=12.4U PD=6.4U
* device instance $18 r0 *1 -4,17.9 NMOS
XM18 AB2 A2_PIN vss vss NMOS L=1U W=3.4U AS=5.1P AD=9.52P PS=6.4U PD=12.4U
* device instance $19 r0 *1 -20,17.9 NMOS
XM19 vss AB3 A3 vss NMOS L=1U W=3.4U AS=9.52P AD=5.1P PS=12.4U PD=6.4U
* device instance $20 r0 *1 -16,17.9 NMOS
XM20 AB3 A3_PIN vss vss NMOS L=1U W=3.4U AS=5.1P AD=9.52P PS=6.4U PD=12.4U
.ENDS ADDBUF
