* Created by KLayout
*** My special header ***

* cell REG4x16
* pin ADD[0]
* pin ADD[1]
* pin ADD[2]
* pin ADD[3]
* pin D[0]
* pin D[1]
* pin D[2]
* pin D[3]
* pin Q[0]
* pin Q[1]
* pin Q[2]
* pin Q[3]
* pin WEB
* pin vdd
* pin vss
.SUBCKT REG4x16 ADD[0] ADD[1] ADD[2] ADD[3] D[0] D[1] D[2] D[3] Q[0] Q[1] Q[2]
+ Q[3] WEB vdd vss
* cell instance $1 r180 *1 -48.6,4.8
X1 nI82 nI79 nI83 nI76 nI78 ADD[3] nI81 ADD[2] ADD[1] nI80 nI75 nI77
+ vdd ADD[0] WEB vss ADDBUF
* cell instance $5 r180 *1 113.4,4.8
X5 nI72 Q[2] nI68 D[2] vdd vss REGBUF
* cell instance $6 r180 *1 75.6,4.8
X6 nI73 Q[1] nI69 D[1] vdd vss REGBUF
* cell instance $7 r180 *1 37.8,4.8
X7 nI74 Q[0] nI70 D[0] vdd vss REGBUF
* cell instance $8 r180 *1 151.2,4.8
X8 nI71 Q[3] nI67 D[3] vdd vss REGBUF
* cell instance $9 m45 *1 -86.4,166.2
X9 vdd nI77 nI76 nI75 nI8 nI16 nI48 nI40 vss nI64 nI32 nI56 nI24
+ nI80 nI81 nI78 DEC2
* cell instance $10 m45 *1 -86.4,57
X10 vdd nI77 nI76 nI75 nI9 nI17 nI49 nI41 vss nI65 nI33 nI57 nI25
+ nI83 nI81 nI78 DEC2
* cell instance $11 m45 *1 -86.4,275.4
X11 vdd nI77 nI76 nI75 nI7 nI15 nI47 nI39 vss nI63 nI31 nI55 nI23
+ nI83 nI79 nI78 DEC2
* cell instance $12 m45 *1 -86.4,384.6
X12 vdd nI77 nI76 nI75 nI6 nI14 nI46 nI38 vss nI62 nI30 nI54 nI22
+ nI80 nI79 nI78 DEC2
* cell instance $13 m45 *1 -86.4,493.8
X13 vdd nI77 nI76 nI75 nI5 nI13 nI45 nI37 vss nI61 nI29 nI53 nI21
+ nI83 nI81 nI82 DEC2
* cell instance $14 m45 *1 -86.4,603
X14 vdd nI77 nI76 nI75 nI4 nI12 nI44 nI36 vss nI60 nI28 nI52 nI20
+ nI80 nI81 nI82 DEC2
* cell instance $15 m45 *1 -86.4,712.2
X15 vdd nI77 nI76 nI75 nI3 nI11 nI43 nI35 vss nI59 nI27 nI51 nI19
+ nI83 nI79 nI82 DEC2
* cell instance $16 m45 *1 -86.4,821.4
X16 vdd nI77 nI76 nI75 nI2 nI10 nI42 nI34 vss nI58 nI26 nI50 nI18
+ nI80 nI79 nI82 DEC2
* cell instance $41 m0 *1 0,223.2
X41 nI32 nI24 nI74 nI70 vdd nI16 nI8 vss TLAT
* cell instance $42 m0 *1 37.8,223.2
X42 nI32 nI24 nI73 nI69 vdd nI16 nI8 vss TLAT
* cell instance $43 m0 *1 75.6,223.2
X43 nI32 nI24 nI72 nI68 vdd nI16 nI8 vss TLAT
* cell instance $44 m0 *1 113.4,223.2
X44 nI32 nI24 nI71 nI67 vdd nI16 nI8 vss TLAT
* cell instance $45 r0 *1 0,109.2
X45 nI64 nI56 nI74 nI70 vdd nI48 nI40 vss TLAT
* cell instance $46 r0 *1 37.8,109.2
X46 nI64 nI56 nI73 nI69 vdd nI48 nI40 vss TLAT
* cell instance $47 r0 *1 75.6,109.2
X47 nI64 nI56 nI72 nI68 vdd nI48 nI40 vss TLAT
* cell instance $48 r0 *1 113.4,109.2
X48 nI64 nI56 nI71 nI67 vdd nI48 nI40 vss TLAT
* cell instance $49 m0 *1 0,114
X49 nI33 nI25 nI74 nI70 vdd nI17 nI9 vss TLAT
* cell instance $50 m0 *1 37.8,114
X50 nI33 nI25 nI73 nI69 vdd nI17 nI9 vss TLAT
* cell instance $51 m0 *1 75.6,114
X51 nI33 nI25 nI72 nI68 vdd nI17 nI9 vss TLAT
* cell instance $52 m0 *1 113.4,114
X52 nI33 nI25 nI71 nI67 vdd nI17 nI9 vss TLAT
* cell instance $53 r0 *1 0,0
X53 nI65 nI57 nI74 nI70 vdd nI49 nI41 vss TLAT
* cell instance $54 r0 *1 37.8,0
X54 nI65 nI57 nI73 nI69 vdd nI49 nI41 vss TLAT
* cell instance $55 r0 *1 75.6,0
X55 nI65 nI57 nI72 nI68 vdd nI49 nI41 vss TLAT
* cell instance $56 r0 *1 113.4,0
X56 nI65 nI57 nI71 nI67 vdd nI49 nI41 vss TLAT
* cell instance $57 m0 *1 0,332.4
X57 nI31 nI23 nI74 nI70 vdd nI15 nI7 vss TLAT
* cell instance $58 m0 *1 37.8,332.4
X58 nI31 nI23 nI73 nI69 vdd nI15 nI7 vss TLAT
* cell instance $59 m0 *1 75.6,332.4
X59 nI31 nI23 nI72 nI68 vdd nI15 nI7 vss TLAT
* cell instance $60 m0 *1 113.4,332.4
X60 nI31 nI23 nI71 nI67 vdd nI15 nI7 vss TLAT
* cell instance $61 r0 *1 0,218.4
X61 nI63 nI55 nI74 nI70 vdd nI47 nI39 vss TLAT
* cell instance $62 r0 *1 37.8,218.4
X62 nI63 nI55 nI73 nI69 vdd nI47 nI39 vss TLAT
* cell instance $63 r0 *1 75.6,218.4
X63 nI63 nI55 nI72 nI68 vdd nI47 nI39 vss TLAT
* cell instance $64 r0 *1 113.4,218.4
X64 nI63 nI55 nI71 nI67 vdd nI47 nI39 vss TLAT
* cell instance $65 m0 *1 0,441.6
X65 nI30 nI22 nI74 nI70 vdd nI14 nI6 vss TLAT
* cell instance $66 m0 *1 37.8,441.6
X66 nI30 nI22 nI73 nI69 vdd nI14 nI6 vss TLAT
* cell instance $67 m0 *1 75.6,441.6
X67 nI30 nI22 nI72 nI68 vdd nI14 nI6 vss TLAT
* cell instance $68 m0 *1 113.4,441.6
X68 nI30 nI22 nI71 nI67 vdd nI14 nI6 vss TLAT
* cell instance $69 r0 *1 0,327.6
X69 nI62 nI54 nI74 nI70 vdd nI46 nI38 vss TLAT
* cell instance $70 r0 *1 37.8,327.6
X70 nI62 nI54 nI73 nI69 vdd nI46 nI38 vss TLAT
* cell instance $71 r0 *1 75.6,327.6
X71 nI62 nI54 nI72 nI68 vdd nI46 nI38 vss TLAT
* cell instance $72 r0 *1 113.4,327.6
X72 nI62 nI54 nI71 nI67 vdd nI46 nI38 vss TLAT
* cell instance $73 m0 *1 0,550.8
X73 nI29 nI21 nI74 nI70 vdd nI13 nI5 vss TLAT
* cell instance $74 m0 *1 37.8,550.8
X74 nI29 nI21 nI73 nI69 vdd nI13 nI5 vss TLAT
* cell instance $75 m0 *1 75.6,550.8
X75 nI29 nI21 nI72 nI68 vdd nI13 nI5 vss TLAT
* cell instance $76 m0 *1 113.4,550.8
X76 nI29 nI21 nI71 nI67 vdd nI13 nI5 vss TLAT
* cell instance $77 r0 *1 0,436.8
X77 nI61 nI53 nI74 nI70 vdd nI45 nI37 vss TLAT
* cell instance $78 r0 *1 37.8,436.8
X78 nI61 nI53 nI73 nI69 vdd nI45 nI37 vss TLAT
* cell instance $79 r0 *1 75.6,436.8
X79 nI61 nI53 nI72 nI68 vdd nI45 nI37 vss TLAT
* cell instance $80 r0 *1 113.4,436.8
X80 nI61 nI53 nI71 nI67 vdd nI45 nI37 vss TLAT
* cell instance $81 m0 *1 0,660
X81 nI28 nI20 nI74 nI70 vdd nI12 nI4 vss TLAT
* cell instance $82 m0 *1 37.8,660
X82 nI28 nI20 nI73 nI69 vdd nI12 nI4 vss TLAT
* cell instance $83 m0 *1 75.6,660
X83 nI28 nI20 nI72 nI68 vdd nI12 nI4 vss TLAT
* cell instance $84 m0 *1 113.4,660
X84 nI28 nI20 nI71 nI67 vdd nI12 nI4 vss TLAT
* cell instance $85 r0 *1 0,546
X85 nI60 nI52 nI74 nI70 vdd nI44 nI36 vss TLAT
* cell instance $86 r0 *1 37.8,546
X86 nI60 nI52 nI73 nI69 vdd nI44 nI36 vss TLAT
* cell instance $87 r0 *1 75.6,546
X87 nI60 nI52 nI72 nI68 vdd nI44 nI36 vss TLAT
* cell instance $88 r0 *1 113.4,546
X88 nI60 nI52 nI71 nI67 vdd nI44 nI36 vss TLAT
* cell instance $89 m0 *1 0,769.2
X89 nI27 nI19 nI74 nI70 vdd nI11 nI3 vss TLAT
* cell instance $90 m0 *1 37.8,769.2
X90 nI27 nI19 nI73 nI69 vdd nI11 nI3 vss TLAT
* cell instance $91 m0 *1 75.6,769.2
X91 nI27 nI19 nI72 nI68 vdd nI11 nI3 vss TLAT
* cell instance $92 m0 *1 113.4,769.2
X92 nI27 nI19 nI71 nI67 vdd nI11 nI3 vss TLAT
* cell instance $93 r0 *1 0,655.2
X93 nI59 nI51 nI74 nI70 vdd nI43 nI35 vss TLAT
* cell instance $94 r0 *1 37.8,655.2
X94 nI59 nI51 nI73 nI69 vdd nI43 nI35 vss TLAT
* cell instance $95 r0 *1 75.6,655.2
X95 nI59 nI51 nI72 nI68 vdd nI43 nI35 vss TLAT
* cell instance $96 r0 *1 113.4,655.2
X96 nI59 nI51 nI71 nI67 vdd nI43 nI35 vss TLAT
* cell instance $97 m0 *1 0,878.4
X97 nI26 nI18 nI74 nI70 vdd nI10 nI2 vss TLAT
* cell instance $98 m0 *1 37.8,878.4
X98 nI26 nI18 nI73 nI69 vdd nI10 nI2 vss TLAT
* cell instance $99 m0 *1 75.6,878.4
X99 nI26 nI18 nI72 nI68 vdd nI10 nI2 vss TLAT
* cell instance $100 m0 *1 113.4,878.4
X100 nI26 nI18 nI71 nI67 vdd nI10 nI2 vss TLAT
* cell instance $101 r0 *1 0,764.4
X101 nI58 nI50 nI74 nI70 vdd nI42 nI34 vss TLAT
* cell instance $102 r0 *1 37.8,764.4
X102 nI58 nI50 nI73 nI69 vdd nI42 nI34 vss TLAT
* cell instance $103 r0 *1 75.6,764.4
X103 nI58 nI50 nI72 nI68 vdd nI42 nI34 vss TLAT
* cell instance $104 r0 *1 113.4,764.4
X104 nI58 nI50 nI71 nI67 vdd nI42 nI34 vss TLAT
.ENDS REG4x16

* cell REGBUF
* pin Q
* pin QQ
* pin DD
* pin D
* pin vdd
* pin vss
.SUBCKT REGBUF Q QQ DD D vdd vss
* device instance $1 r0 *1 29.8,47.8 PMOS
XM1 DD n6 vdd vdd PMOS L=1u W=10.2u AS=28.56p AD=15.3p PS=26u PD=13.2u
* device instance $2 r0 *1 33.8,47.8 PMOS
XM2 vdd D n6 vdd PMOS L=1u W=10.2u AS=15.3p AD=28.56p PS=13.2u PD=26u
* device instance $3 r0 *1 4,47.8 PMOS
XM3 n3 Q vdd vdd PMOS L=1u W=10.2u AS=28.56p AD=15.3p PS=26u PD=13.2u
* device instance $4 r0 *1 8,47.8 PMOS
XM4 vdd n3 QQ vdd PMOS L=1u W=10.2u AS=15.3p AD=28.56p PS=13.2u PD=26u
* device instance $5 r0 *1 5.4,8.2 NMOS
XM5 n3 Q vss vss NMOS L=1u W=3.4u AS=9.52p AD=5.1p PS=12.4u PD=6.4u
* device instance $6 r0 *1 9.4,8.2 NMOS
XM6 vss n3 QQ vss NMOS L=1u W=3.4u AS=5.1p AD=9.52p PS=6.4u PD=12.4u
* device instance $7 r0 *1 28.4,8.2 NMOS
XM7 DD n6 vss vss NMOS L=1u W=3.4u AS=9.52p AD=5.1p PS=12.4u PD=6.4u
* device instance $8 r0 *1 32.4,8.2 NMOS
XM8 vss D n6 vss NMOS L=1u W=3.4u AS=5.1p AD=9.52p PS=6.4u PD=12.4u
.ENDS REGBUF

* cell DEC2
* pin
* pin WEB
* pin AB0
* pin A0
* pin
* pin
* pin
* pin
* pin VSS
* pin
* pin
* pin
* pin
* pin
* pin
* pin
.SUBCKT DEC2 n1 WEB AB0 A0 n16 n18 n20 n28 VSS nI54 nI53 nI52 nI51
+ nI41 nI40 nI27
* device instance $1 r0 *1 -22.2,68.8 PMOS
XM1 n28 n20 n21 n1 PMOS L=1u W=12.2u AS=34.16p AD=7.32p PS=30u PD=13.4u
* device instance $2 r0 *1 -20,68.8 PMOS
XM2 n21 WEB n1 n1 PMOS L=1u W=12.2u AS=7.32p AD=30.5p PS=13.4u PD=17.2u
* device instance $3 r0 *1 -14,68.8 PMOS
XM3 n1 AB0 n20 n1 PMOS L=1u W=12.2u AS=30.5p AD=18.3p PS=17.2u PD=15.2u
* device instance $4 r0 *1 -10,68.8 PMOS
XM4 n20 nI41 n1 n1 PMOS L=1u W=12.2u AS=18.3p AD=18.3p PS=15.2u PD=15.2u
* device instance $5 r0 *1 -6,68.8 PMOS
XM5 n1 nI40 n20 n1 PMOS L=1u W=12.2u AS=18.3p AD=18.3p PS=15.2u PD=15.2u
* device instance $6 r0 *1 -2,68.8 PMOS
XM6 n20 nI27 n1 n1 PMOS L=1u W=12.2u AS=18.3p AD=18.3p PS=15.2u PD=15.2u
* device instance $7 r0 *1 2,68.8 PMOS
XM7 n1 nI27 n18 n1 PMOS L=1u W=12.2u AS=18.3p AD=18.3p PS=15.2u PD=15.2u
* device instance $8 r0 *1 6,68.8 PMOS
XM8 n18 nI40 n1 n1 PMOS L=1u W=12.2u AS=18.3p AD=18.3p PS=15.2u PD=15.2u
* device instance $9 r0 *1 10,68.8 PMOS
XM9 n1 nI41 n18 n1 PMOS L=1u W=12.2u AS=18.3p AD=18.3p PS=15.2u PD=15.2u
* device instance $10 r0 *1 14,68.8 PMOS
XM10 n18 A0 n1 n1 PMOS L=1u W=12.2u AS=18.3p AD=30.5p PS=15.2u PD=17.2u
* device instance $11 r0 *1 20,68.8 PMOS
XM11 n1 WEB n17 n1 PMOS L=1u W=12.2u AS=30.5p AD=7.32p PS=17.2u PD=13.4u
* device instance $12 r0 *1 22.2,68.8 PMOS
XM12 n17 n18 n16 n1 PMOS L=1u W=12.2u AS=7.32p AD=34.16p PS=13.4u PD=30u
* device instance $13 r0 *1 -9.6,12.4 NMOS
XM13 n20 AB0 n32 VSS NMOS L=1u W=4.6u AS=12.88p AD=2.76p PS=14.8u PD=5.8u
* device instance $14 r0 *1 -7.4,12.4 NMOS
XM14 n32 nI41 n31 VSS NMOS L=1u W=4.6u AS=2.76p AD=2.76p PS=5.8u PD=5.8u
* device instance $15 r0 *1 -5.2,12.4 NMOS
XM15 n31 nI40 n36 VSS NMOS L=1u W=4.6u AS=2.76p AD=2.76p PS=5.8u PD=5.8u
* device instance $16 r0 *1 -3,12.4 NMOS
XM16 n36 nI27 VSS VSS NMOS L=1u W=4.6u AS=2.76p AD=11.5p PS=5.8u PD=9.6u
* device instance $17 r0 *1 3,12.4 NMOS
XM17 VSS nI27 n35 VSS NMOS L=1u W=4.6u AS=11.5p AD=2.76p PS=9.6u PD=5.8u
* device instance $18 r0 *1 5.2,12.4 NMOS
XM18 n35 nI40 n29 VSS NMOS L=1u W=4.6u AS=2.76p AD=2.76p PS=5.8u PD=5.8u
* device instance $19 r0 *1 7.4,12.4 NMOS
XM19 n29 nI41 n30 VSS NMOS L=1u W=4.6u AS=2.76p AD=2.76p PS=5.8u PD=5.8u
* device instance $20 r0 *1 9.6,12.4 NMOS
XM20 n30 A0 n18 VSS NMOS L=1u W=4.6u AS=2.76p AD=12.88p PS=5.8u PD=14.8u
* device instance $21 r0 *1 30.2,68.8 PMOS
XM21 nI51 n16 n1 n1 PMOS L=1u W=12.2u AS=34.16p AD=18.3p PS=30u PD=15.2u
* device instance $22 r0 *1 34.2,68.8 PMOS
XM22 n1 n18 nI53 n1 PMOS L=1u W=12.2u AS=18.3p AD=34.16p PS=15.2u PD=30u
* device instance $23 r0 *1 30.2,26.9 NMOS
XM23 nI51 n16 VSS VSS NMOS L=1u W=4.6u AS=12.88p AD=6.9p PS=14.8u PD=7.6u
* device instance $24 r0 *1 34.2,26.9 NMOS
XM24 VSS n18 nI53 VSS NMOS L=1u W=4.6u AS=6.9p AD=12.88p PS=7.6u PD=14.8u
* device instance $25 r0 *1 22.2,26.9 NMOS
XM25 VSS n18 n16 VSS NMOS L=1u W=4.6u AS=12.88p AD=12.88p PS=14.8u PD=14.8u
* device instance $26 r0 *1 22.2,12.4 NMOS
XM26 VSS WEB n16 VSS NMOS L=1u W=4.6u AS=12.88p AD=12.88p PS=14.8u PD=14.8u
* device instance $27 m90 *1 -30.2,68.8 PMOS
XM27 nI52 n28 n1 n1 PMOS L=1u W=12.2u AS=34.16p AD=18.3p PS=30u PD=15.2u
* device instance $28 m90 *1 -34.2,68.8 PMOS
XM28 n1 n20 nI54 n1 PMOS L=1u W=12.2u AS=18.3p AD=34.16p PS=15.2u PD=30u
* device instance $29 m90 *1 -30.2,26.9 NMOS
XM29 nI52 n28 VSS VSS NMOS L=1u W=4.6u AS=12.88p AD=6.9p PS=14.8u PD=7.6u
* device instance $30 m90 *1 -34.2,26.9 NMOS
XM30 VSS n20 nI54 VSS NMOS L=1u W=4.6u AS=6.9p AD=12.88p PS=7.6u PD=14.8u
* device instance $31 m90 *1 -22.2,26.9 NMOS
XM31 VSS n20 n28 VSS NMOS L=1u W=4.6u AS=12.88p AD=12.88p PS=14.8u PD=14.8u
* device instance $32 m90 *1 -22.2,12.4 NMOS
XM32 VSS WEB n28 VSS NMOS L=1u W=4.6u AS=12.88p AD=12.88p PS=14.8u PD=14.8u
.ENDS DEC2

* cell TLAT
* pin RD
* pin WRB
* pin Q
* pin D
* pin vdd
* pin RDB
* pin WR
* pin vss
.SUBCKT TLAT RD WRB Q D vdd RDB WR vss
* device instance $1 r0 *1 29.5,40.2 PMOS
XM1 vdd n6 n7 vdd PMOS L=1u W=7.2u AS=20.16p AD=10.8p PS=20u PD=10.2u
* device instance $2 r0 *1 33.5,40.2 PMOS
XM2 n7 RDB Q vdd PMOS L=1u W=7.2u AS=10.8p AD=20.16p PS=10.2u PD=20u
* device instance $3 r0 *1 9.5,40.2 PMOS
XM3 D WRB n4 vdd PMOS L=1u W=7.2u AS=20.16p AD=10.8p PS=20u PD=10.2u
* device instance $4 r0 *1 13.5,40.2 PMOS
XM4 n4 WR n5 vdd PMOS L=1u W=7.2u AS=10.8p AD=10.8p PS=10.2u PD=10.2u
* device instance $5 r0 *1 17.5,40.2 PMOS
XM5 n5 n6 vdd vdd PMOS L=1u W=7.2u AS=10.8p AD=10.8p PS=10.2u PD=10.2u
* device instance $6 r0 *1 21.5,40.2 PMOS
XM6 vdd n4 n6 vdd PMOS L=1u W=7.2u AS=10.8p AD=20.16p PS=10.2u PD=20u
* device instance $7 r0 *1 29.5,17.9 NMOS
XM7 vss n6 n7 vss NMOS L=1u W=3.4u AS=9.52p AD=5.1p PS=12.4u PD=6.4u
* device instance $8 r0 *1 33.5,17.9 NMOS
XM8 n7 RD Q vss NMOS L=1u W=3.4u AS=5.1p AD=9.52p PS=6.4u PD=12.4u
* device instance $9 r0 *1 9.5,17.9 NMOS
XM9 D WR n4 vss NMOS L=1u W=3.4u AS=9.52p AD=5.1p PS=12.4u PD=6.4u
* device instance $10 r0 *1 13.5,17.9 NMOS
XM10 n4 WRB n5 vss NMOS L=1u W=3.4u AS=5.1p AD=5.1p PS=6.4u PD=6.4u
* device instance $11 r0 *1 17.5,17.9 NMOS
XM11 n5 n6 vss vss NMOS L=1u W=3.4u AS=5.1p AD=5.1p PS=6.4u PD=6.4u
* device instance $12 r0 *1 21.5,17.9 NMOS
XM12 vss n4 n6 vss NMOS L=1u W=3.4u AS=5.1p AD=9.52p PS=6.4u PD=12.4u
.ENDS TLAT

* cell ADDBUF
* pin AB3
* pin AB2
* pin AB1
* pin AB0
* pin A3
* pin A3_PIN
* pin A2
* pin A2_PIN
* pin A1_PIN
* pin A1
* pin A0
* pin WEB
* pin vdd
* pin A0_PIN
* pin WEB_PIN
* pin vss
.SUBCKT ADDBUF AB3 AB2 AB1 AB0 A3 A3_PIN A2 A2_PIN A1_PIN A1 A0 WEB vdd A0_PIN
+ WEB_PIN vss
* device instance $1 r0 *1 -20,41.7 PMOS
XM1 A3 AB3 vdd vdd PMOS L=1u W=10.2u AS=28.56p AD=15.3p PS=26u PD=13.2u
* device instance $2 r0 *1 -16,41.7 PMOS
XM2 vdd A3_PIN AB3 vdd PMOS L=1u W=10.2u AS=15.3p AD=28.56p PS=13.2u PD=26u
* device instance $3 r0 *1 16,41.7 PMOS
XM3 AB0 A0_PIN vdd vdd PMOS L=1u W=10.2u AS=28.56p AD=15.3p PS=26u PD=13.2u
* device instance $4 r0 *1 20,41.7 PMOS
XM4 vdd AB0 A0 vdd PMOS L=1u W=10.2u AS=15.3p AD=28.56p PS=13.2u PD=26u
* device instance $5 r0 *1 28,41.7 PMOS
XM5 WEB n6 vdd vdd PMOS L=1u W=10.2u AS=28.56p AD=15.3p PS=26u PD=13.2u
* device instance $6 r0 *1 32,41.7 PMOS
XM6 vdd WEB_PIN n6 vdd PMOS L=1u W=10.2u AS=15.3p AD=28.56p PS=13.2u PD=26u
* device instance $7 r0 *1 4,41.7 PMOS
XM7 AB1 A1_PIN vdd vdd PMOS L=1u W=10.2u AS=28.56p AD=15.3p PS=26u PD=13.2u
* device instance $8 r0 *1 8,41.7 PMOS
XM8 vdd AB1 A1 vdd PMOS L=1u W=10.2u AS=15.3p AD=28.56p PS=13.2u PD=26u
* device instance $9 r0 *1 -8,41.7 PMOS
XM9 A2 AB2 vdd vdd PMOS L=1u W=10.2u AS=28.56p AD=15.3p PS=26u PD=13.2u
* device instance $10 r0 *1 -4,41.7 PMOS
XM10 vdd A2_PIN AB2 vdd PMOS L=1u W=10.2u AS=15.3p AD=28.56p PS=13.2u PD=26u
* device instance $11 r0 *1 28,17.9 NMOS
XM11 WEB n6 vss vss NMOS L=1u W=3.4u AS=9.52p AD=5.1p PS=12.4u PD=6.4u
* device instance $12 r0 *1 32,17.9 NMOS
XM12 vss WEB_PIN n6 vss NMOS L=1u W=3.4u AS=5.1p AD=9.52p PS=6.4u PD=12.4u
* device instance $13 r0 *1 16,17.9 NMOS
XM13 AB0 A0_PIN vss vss NMOS L=1u W=3.4u AS=9.52p AD=5.1p PS=12.4u PD=6.4u
* device instance $14 r0 *1 20,17.9 NMOS
XM14 vss AB0 A0 vss NMOS L=1u W=3.4u AS=5.1p AD=9.52p PS=6.4u PD=12.4u
* device instance $15 r0 *1 4,17.9 NMOS
XM15 AB1 A1_PIN vss vss NMOS L=1u W=3.4u AS=9.52p AD=5.1p PS=12.4u PD=6.4u
* device instance $16 r0 *1 8,17.9 NMOS
XM16 vss AB1 A1 vss NMOS L=1u W=3.4u AS=5.1p AD=9.52p PS=6.4u PD=12.4u
* device instance $17 r0 *1 -8,17.9 NMOS
XM17 A2 AB2 vss vss NMOS L=1u W=3.4u AS=9.52p AD=5.1p PS=12.4u PD=6.4u
* device instance $18 r0 *1 -4,17.9 NMOS
XM18 vss A2_PIN AB2 vss NMOS L=1u W=3.4u AS=5.1p AD=9.52p PS=6.4u PD=12.4u
* device instance $19 r0 *1 -20,17.9 NMOS
XM19 A3 AB3 vss vss NMOS L=1u W=3.4u AS=9.52p AD=5.1p PS=12.4u PD=6.4u
* device instance $20 r0 *1 -16,17.9 NMOS
XM20 vss A3_PIN AB3 vss NMOS L=1u W=3.4u AS=5.1p AD=9.52p PS=6.4u PD=12.4u
.ENDS ADDBUF
