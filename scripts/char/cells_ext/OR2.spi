* Created by KLayout
*** My special header ***

* cell OR2
* pin A
* pin B
* pin Y
* pin vss
* pin vdd
.SUBCKT OR2 A B Y vss vdd
* device instance $1 r0 *1 4,47.8 PMOS
XM1 n3 A n7 vdd PMOS L=1u W=10.2u AS=28.56p AD=6.12p PS=26u PD=11.4u
* device instance $2 r0 *1 6.2,47.8 PMOS
XM2 n7 B vdd vdd PMOS L=1u W=10.2u AS=6.12p AD=15.3p PS=11.4u PD=13.2u
* device instance $3 r0 *1 10.2,47.8 PMOS
XM3 vdd n3 Y vdd PMOS L=1u W=10.2u AS=15.3p AD=28.56p PS=13.2u PD=26u
* device instance $4 r0 *1 4,8.2 NMOS
XM4 vss A n3 vss NMOS L=1u W=3.4u AS=9.52p AD=5.1p PS=12.4u PD=6.4u
* device instance $5 r0 *1 8,8.2 NMOS
XM5 n3 B vss vss NMOS L=1u W=3.4u AS=5.1p AD=5.1p PS=6.4u PD=6.4u
* device instance $6 r0 *1 12,8.2 NMOS
XM6 vss n3 Y vss NMOS L=1u W=3.4u AS=5.1p AD=9.52p PS=6.4u PD=12.4u
.ENDS OR2
