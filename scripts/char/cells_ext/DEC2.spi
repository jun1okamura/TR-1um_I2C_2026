* TR-1um DEC2 — KLayout 抽出 (scripts/klayout_extract.py)

* cell DEC2
* pin A0
* pin AB0
* pin VSS
* pin WEB
.SUBCKT DEC2 A0 AB0 VSS WEB
* cell instance $1 m90 *1 0,0
X1 VSS n22 n28 WEB n1 n1 VSS DEC0
* cell instance $2 r0 *1 0,0
X2 VSS n18 n16 WEB n1 n1 VSS DEC0
* device instance $1 r0 *1 -22.2,68.8 PMOS
XM1 n27 n22 n28 n1 PMOS L=1U W=12.2U AS=34.16P AD=7.32P PS=30U PD=13.4U
* device instance $2 r0 *1 -20,68.8 PMOS
XM2 n1 WEB n27 n1 PMOS L=1U W=12.2U AS=7.32P AD=30.5P PS=13.4U PD=17.2U
* device instance $3 r0 *1 -14,68.8 PMOS
XM3 n22 AB0 n1 n1 PMOS L=1U W=12.2U AS=30.5P AD=18.3P PS=17.2U PD=15.2U
* device instance $4 r0 *1 -10,68.8 PMOS
XM4 n1 nI41 n22 n1 PMOS L=1U W=12.2U AS=18.3P AD=18.3P PS=15.2U PD=15.2U
* device instance $5 r0 *1 -6,68.8 PMOS
XM5 n22 nI40 n1 n1 PMOS L=1U W=12.2U AS=18.3P AD=18.3P PS=15.2U PD=15.2U
* device instance $6 r0 *1 -2,68.8 PMOS
XM6 n1 nI27 n22 n1 PMOS L=1U W=12.2U AS=18.3P AD=18.3P PS=15.2U PD=15.2U
* device instance $7 r0 *1 2,68.8 PMOS
XM7 n18 nI27 n1 n1 PMOS L=1U W=12.2U AS=18.3P AD=18.3P PS=15.2U PD=15.2U
* device instance $8 r0 *1 6,68.8 PMOS
XM8 n1 nI40 n18 n1 PMOS L=1U W=12.2U AS=18.3P AD=18.3P PS=15.2U PD=15.2U
* device instance $9 r0 *1 10,68.8 PMOS
XM9 n18 nI41 n1 n1 PMOS L=1U W=12.2U AS=18.3P AD=18.3P PS=15.2U PD=15.2U
* device instance $10 r0 *1 14,68.8 PMOS
XM10 n1 A0 n18 n1 PMOS L=1U W=12.2U AS=18.3P AD=30.5P PS=15.2U PD=17.2U
* device instance $11 r0 *1 20,68.8 PMOS
XM11 n23 WEB n1 n1 PMOS L=1U W=12.2U AS=30.5P AD=7.32P PS=17.2U PD=13.4U
* device instance $12 r0 *1 22.2,68.8 PMOS
XM12 n16 n18 n23 n1 PMOS L=1U W=12.2U AS=7.32P AD=34.16P PS=13.4U PD=30U
* device instance $13 r0 *1 -9.6,12.4 NMOS
XM13 n35 AB0 n22 VSS NMOS L=1U W=4.6U AS=12.88P AD=2.76P PS=14.8U PD=5.8U
* device instance $14 r0 *1 -7.4,12.4 NMOS
XM14 n34 nI41 n35 VSS NMOS L=1U W=4.6U AS=2.76P AD=2.76P PS=5.8U PD=5.8U
* device instance $15 r0 *1 -5.2,12.4 NMOS
XM15 n36 nI40 n34 VSS NMOS L=1U W=4.6U AS=2.76P AD=2.76P PS=5.8U PD=5.8U
* device instance $16 r0 *1 -3,12.4 NMOS
XM16 VSS nI27 n36 VSS NMOS L=1U W=4.6U AS=2.76P AD=11.5P PS=5.8U PD=9.6U
* device instance $17 r0 *1 3,12.4 NMOS
XM17 n33 nI27 VSS VSS NMOS L=1U W=4.6U AS=11.5P AD=2.76P PS=9.6U PD=5.8U
* device instance $18 r0 *1 5.2,12.4 NMOS
XM18 n30 nI40 n33 VSS NMOS L=1U W=4.6U AS=2.76P AD=2.76P PS=5.8U PD=5.8U
* device instance $19 r0 *1 7.4,12.4 NMOS
XM19 n32 nI41 n30 VSS NMOS L=1U W=4.6U AS=2.76P AD=2.76P PS=5.8U PD=5.8U
* device instance $20 r0 *1 9.6,12.4 NMOS
XM20 n18 A0 n32 VSS NMOS L=1U W=4.6U AS=2.76P AD=12.88P PS=5.8U PD=14.8U
.ENDS DEC2

* cell DEC0
* pin vss
* pin RDB
* pin WR
* pin
* pin vdd
* pin
* pin vss
.SUBCKT DEC0 vss RDB WR n6 vdd n15 vss_1
* device instance $1 r0 *1 30.2,68.8 PMOS
XM1 vdd WR WRB n15 PMOS L=1U W=12.2U AS=34.16P AD=18.3P PS=30U PD=15.2U
* device instance $2 r0 *1 34.2,68.8 PMOS
XM2 RD RDB vdd n15 PMOS L=1U W=12.2U AS=18.3P AD=34.16P PS=15.2U PD=30U
* device instance $3 r0 *1 30.2,26.9 NMOS
XM3 vss WR WRB vss_1 NMOS L=1U W=4.6U AS=12.88P AD=6.9P PS=14.8U PD=7.6U
* device instance $4 r0 *1 34.2,26.9 NMOS
XM4 RD RDB vss vss_1 NMOS L=1U W=4.6U AS=6.9P AD=12.88P PS=7.6U PD=14.8U
* device instance $5 r0 *1 22.2,26.9 NMOS
XM5 WR RDB vss vss_1 NMOS L=1U W=4.6U AS=12.88P AD=12.88P PS=14.8U PD=14.8U
* device instance $6 r0 *1 22.2,12.4 NMOS
XM6 WR n6 vss vss_1 NMOS L=1U W=4.6U AS=12.88P AD=12.88P PS=14.8U PD=14.8U
.ENDS DEC0
