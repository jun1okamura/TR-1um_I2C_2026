* Created by KLayout
*** My special header ***

* cell MUX2
* pin A
* pin B
* pin S
* pin Y
* pin vss
* pin vdd
.SUBCKT MUX2 A B S Y vss vdd
* device instance $1 r0 *1 5.1,50.3 PMOS
XM1 vdd S n3 vdd PMOS L=1u W=5.2u AS=14.56p AD=14.56p PS=16u PD=16u
* device instance $2 r0 *1 27.3,42.2 PMOS
XM2 vdd n6 Y vdd PMOS L=1u W=11.2u AS=31.36p AD=31.36p PS=28u PD=28u
* device instance $3 r0 *1 5.1,39.2 PMOS
XM3 vdd A n5 vdd PMOS L=1u W=5.2u AS=14.56p AD=7.8p PS=16u PD=8.2u
* device instance $4 r0 *1 9.1,39.2 PMOS
XM4 n5 S n6 vdd PMOS L=1u W=5.2u AS=7.8p AD=7.8p PS=8.2u PD=8.2u
* device instance $5 r0 *1 13.1,39.2 PMOS
XM5 n6 n3 n7 vdd PMOS L=1u W=5.2u AS=7.8p AD=7.8p PS=8.2u PD=8.2u
* device instance $6 r0 *1 17.1,39.2 PMOS
XM6 n7 B vdd vdd PMOS L=1u W=5.2u AS=7.8p AD=15.6p PS=8.2u PD=16.4u
* device instance $7 r0 *1 27.3,17.9 NMOS
XM7 vss n6 Y vss NMOS L=1u W=3.4u AS=9.52p AD=9.52p PS=12.4u PD=12.4u
* device instance $8 r0 *1 5.1,17.9 NMOS
XM8 vss A n5 vss NMOS L=1u W=3.4u AS=9.52p AD=5.1p PS=12.4u PD=6.4u
* device instance $9 r0 *1 9.1,17.9 NMOS
XM9 n5 n3 n6 vss NMOS L=1u W=3.4u AS=5.1p AD=5.1p PS=6.4u PD=6.4u
* device instance $10 r0 *1 13.1,17.9 NMOS
XM10 n6 S n7 vss NMOS L=1u W=3.4u AS=5.1p AD=5.1p PS=6.4u PD=6.4u
* device instance $11 r0 *1 17.1,17.9 NMOS
XM11 n7 B vss vss NMOS L=1u W=3.4u AS=5.1p AD=9.52p PS=6.4u PD=12.4u
* device instance $12 r0 *1 11.5,8.2 NMOS
XM12 vss S n3 vss NMOS L=1u W=3.4u AS=10.2p AD=9.52p PS=12.8u PD=12.4u
.ENDS MUX2
