* TR-1um DEC0 — KLayout 抽出 (scripts/klayout_extract.py)

* cell DEC0
* pin RD
* pin RDB
* pin WR
* pin WRB
* pin vdd
* pin vss
* pin vss
.SUBCKT DEC0 RD RDB WR WRB vdd vss vss_1
* device instance $1 r0 *1 2,68.8 PMOS
XM1 RDB n16 vdd n19 PMOS L=1U W=12.2U AS=34.16P AD=18.3P PS=30U PD=15.2U
* device instance $2 r0 *1 6,68.8 PMOS
XM2 vdd n13 RDB n19 PMOS L=1U W=12.2U AS=18.3P AD=18.3P PS=15.2U PD=15.2U
* device instance $3 r0 *1 10,68.8 PMOS
XM3 RDB n14 vdd n19 PMOS L=1U W=12.2U AS=18.3P AD=18.3P PS=15.2U PD=15.2U
* device instance $4 r0 *1 14,68.8 PMOS
XM4 vdd n5 RDB n19 PMOS L=1U W=12.2U AS=18.3P AD=30.5P PS=15.2U PD=17.2U
* device instance $5 r0 *1 20,68.8 PMOS
XM5 n18 n6 vdd n19 PMOS L=1U W=12.2U AS=30.5P AD=7.32P PS=17.2U PD=13.4U
* device instance $6 r0 *1 22.2,68.8 PMOS
XM6 WR RDB n18 n19 PMOS L=1U W=12.2U AS=7.32P AD=34.16P PS=13.4U PD=30U
* device instance $7 r0 *1 30.2,68.8 PMOS
XM7 vdd WR WRB n19 PMOS L=1U W=12.2U AS=34.16P AD=18.3P PS=30U PD=15.2U
* device instance $8 r0 *1 34.2,68.8 PMOS
XM8 RD RDB vdd n19 PMOS L=1U W=12.2U AS=18.3P AD=34.16P PS=15.2U PD=30U
* device instance $9 r0 *1 22.2,26.9 NMOS
XM9 WR RDB vss vss_1 NMOS L=1U W=4.6U AS=12.88P AD=12.88P PS=14.8U PD=14.8U
* device instance $10 r0 *1 30.2,26.9 NMOS
XM10 vss WR WRB vss_1 NMOS L=1U W=4.6U AS=12.88P AD=6.9P PS=14.8U PD=7.6U
* device instance $11 r0 *1 34.2,26.9 NMOS
XM11 RD RDB vss vss_1 NMOS L=1U W=4.6U AS=6.9P AD=12.88P PS=7.6U PD=14.8U
* device instance $12 r0 *1 22.2,12.4 NMOS
XM12 WR n6 vss vss_1 NMOS L=1U W=4.6U AS=12.88P AD=12.88P PS=14.8U PD=14.8U
* device instance $13 r0 *1 3,12.4 NMOS
XM13 n10 n16 vss vss_1 NMOS L=1U W=4.6U AS=12.88P AD=2.76P PS=14.8U PD=5.8U
* device instance $14 r0 *1 5.2,12.4 NMOS
XM14 n11 n13 n10 vss_1 NMOS L=1U W=4.6U AS=2.76P AD=2.76P PS=5.8U PD=5.8U
* device instance $15 r0 *1 7.4,12.4 NMOS
XM15 n12 n14 n11 vss_1 NMOS L=1U W=4.6U AS=2.76P AD=2.76P PS=5.8U PD=5.8U
* device instance $16 r0 *1 9.6,12.4 NMOS
XM16 RDB n5 n12 vss_1 NMOS L=1U W=4.6U AS=2.76P AD=12.88P PS=5.8U PD=14.8U
.ENDS DEC0
