* Created by KLayout
*** My special header ***

* cell DFF
* pin CK
* pin CKB
* pin CKP
* pin D
* pin Q
* pin QB
* pin QM
* pin QS
* pin vss
* pin vdd
.SUBCKT DFF CK CKB CKP D Q QB QM QS vss vdd
* device instance $1 r0 *1 59.7,41.8 PMOS
XM1 vdd QB Q vdd PMOS L=1u W=10.4u AS=29.12p AD=29.12p PS=26.4u PD=26.4u
* device instance $2 r0 *1 4,41.8 PMOS
XM2 CKB CK vdd vdd PMOS L=1u W=10.4u AS=29.12p AD=15.6p PS=26.4u PD=13.4u
* device instance $3 r0 *1 8,41.8 PMOS
XM3 vdd CKB CKP vdd PMOS L=1u W=10.4u AS=15.6p AD=29.12p PS=13.4u PD=26.4u
* device instance $4 r0 *1 16,39.2 PMOS
XM4 vdd D n14 vdd PMOS L=1u W=5.2u AS=14.56p AD=3.12p PS=16u PD=6.4u
* device instance $5 r0 *1 18.2,39.2 PMOS
XM5 n14 CKP n6 vdd PMOS L=1u W=5.2u AS=3.12p AD=7.8p PS=6.4u PD=8.2u
* device instance $6 r0 *1 22.2,39.2 PMOS
XM6 n6 CKB n7 vdd PMOS L=1u W=5.2u AS=7.8p AD=7.8p PS=8.2u PD=8.2u
* device instance $7 r0 *1 26.2,39.2 PMOS
XM7 n7 QM vdd vdd PMOS L=1u W=5.2u AS=7.8p AD=7.8p PS=8.2u PD=8.2u
* device instance $8 r0 *1 30.2,39.2 PMOS
XM8 vdd n6 QM vdd PMOS L=1u W=5.2u AS=7.8p AD=7.8p PS=8.2u PD=8.2u
* device instance $9 r0 *1 34.2,39.2 PMOS
XM9 QM CKB QS vdd PMOS L=1u W=5.2u AS=7.8p AD=7.8p PS=8.2u PD=8.2u
* device instance $10 r0 *1 38.2,39.2 PMOS
XM10 QS CKP n9 vdd PMOS L=1u W=5.2u AS=7.8p AD=7.8p PS=8.2u PD=8.2u
* device instance $11 r0 *1 42.2,39.2 PMOS
XM11 n9 QB vdd vdd PMOS L=1u W=5.2u AS=7.8p AD=14.56p PS=8.2u PD=16u
* device instance $12 r0 *1 51.7,41.8 PMOS
XM12 vdd QS QB vdd PMOS L=1u W=10.4u AS=29.12p AD=29.12p PS=26.4u PD=26.4u
* device instance $13 r0 *1 51.7,17.9 NMOS
XM13 vss QS QB vss NMOS L=1u W=3.4u AS=9.52p AD=9.52p PS=12.4u PD=12.4u
* device instance $14 r0 *1 16,17.9 NMOS
XM14 vss D n13 vss NMOS L=1u W=3.4u AS=9.52p AD=2.04p PS=12.4u PD=4.6u
* device instance $15 r0 *1 18.2,17.9 NMOS
XM15 n13 CKB n6 vss NMOS L=1u W=3.4u AS=2.04p AD=5.1p PS=4.6u PD=6.4u
* device instance $16 r0 *1 22.2,17.9 NMOS
XM16 n6 CKP n7 vss NMOS L=1u W=3.4u AS=5.1p AD=5.1p PS=6.4u PD=6.4u
* device instance $17 r0 *1 26.2,17.9 NMOS
XM17 n7 QM vss vss NMOS L=1u W=3.4u AS=5.1p AD=5.1p PS=6.4u PD=6.4u
* device instance $18 r0 *1 30.2,17.9 NMOS
XM18 vss n6 QM vss NMOS L=1u W=3.4u AS=5.1p AD=5.1p PS=6.4u PD=6.4u
* device instance $19 r0 *1 34.2,17.9 NMOS
XM19 QM CKP QS vss NMOS L=1u W=3.4u AS=5.1p AD=5.1p PS=6.4u PD=6.4u
* device instance $20 r0 *1 38.2,17.9 NMOS
XM20 QS CKB n9 vss NMOS L=1u W=3.4u AS=5.1p AD=5.1p PS=6.4u PD=6.4u
* device instance $21 r0 *1 42.2,17.9 NMOS
XM21 n9 QB vss vss NMOS L=1u W=3.4u AS=5.1p AD=9.52p PS=6.4u PD=12.4u
* device instance $22 r0 *1 59.7,17.9 NMOS
XM22 vss QB Q vss NMOS L=1u W=3.4u AS=9.52p AD=9.52p PS=12.4u PD=12.4u
* device instance $23 r0 *1 4,17.9 NMOS
XM23 CKB CK vss vss NMOS L=1u W=3.4u AS=9.52p AD=5.1p PS=12.4u PD=6.4u
* device instance $24 r0 *1 8,17.9 NMOS
XM24 vss CKB CKP vss NMOS L=1u W=3.4u AS=5.1p AD=9.52p PS=6.4u PD=12.4u
.ENDS DFF
