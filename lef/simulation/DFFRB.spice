* DFFRB — LVS ソースネットリスト
* scripts/char/mkcellspice.py が生成。手で編集しないこと。
*
* 出どころ: **レイアウト抽出を golden として凍結したもの**。
*   このセルは同じ論理でも CMOS 構造が一意に決まらない（回路図が無い）。
*   29T。DFF + 非同期リセット（RSTB=0 で Q=0）。
*
*   ** この .spice に対する LVS は「レイアウト vs そのレイアウトから作った網」
*      なので、今この瞬間は何も証明しない。意味があるのは
*      次にレイアウトを触ったときに差分が出ること（回帰検査）。**
*
*   凍結した時点で ngspice により機能を確認済み:
*   真理値表 436 点 / 順序 87 点 すべて PASS（scripts/char/RESULTS.txt）。
*
.subckt DFFRB CK RSTB D QB Q vdd vss
MP0 vdd QS QB vdd PMOS W=5.2u L=1.0u
MP1 vdd RSTB QB vdd PMOS W=5.2u L=1.0u
MP2 vdd QB Q vdd PMOS W=5.2u L=1.0u
MP3 vdd CK CKB vdd PMOS W=10.4u L=1.0u
MP4 vdd CKB CKP vdd PMOS W=10.4u L=1.0u
MP5 vdd D n6 vdd PMOS W=5.2u L=1.0u
MP6 n6 CKP n4 vdd PMOS W=5.2u L=1.0u
MP7 n4 CKB n3 vdd PMOS W=5.2u L=1.0u
MP8 vdd QM n3 vdd PMOS W=5.2u L=1.0u
MP9 vdd n4 QM vdd PMOS W=5.2u L=1.0u
MP10 QS CKB QM vdd PMOS W=5.2u L=1.0u
MP11 n2 CKP QS vdd PMOS W=5.2u L=1.0u
MP12 vdd QB n2 vdd PMOS W=5.2u L=1.0u
MP13 vdd QS QB vdd PMOS W=5.2u L=1.0u
MP14 vdd RSTB QB vdd PMOS W=5.2u L=1.0u
MP15 vdd QB Q vdd PMOS W=5.2u L=1.0u
MN0 vss CK CKB vss NMOS W=3.4u L=1.0u
MN1 vss CKB CKP vss NMOS W=3.4u L=1.0u
MN2 vss QB Q vss NMOS W=3.4u L=1.0u
MN3 n5 D vss vss NMOS W=3.4u L=1.0u
MN4 n5 CKB n4 vss NMOS W=3.4u L=1.0u
MN5 n4 CKP n3 vss NMOS W=3.4u L=1.0u
MN6 n3 QM vss vss NMOS W=3.4u L=1.0u
MN7 vss n4 QM vss NMOS W=3.4u L=1.0u
MN8 QS CKP QM vss NMOS W=3.4u L=1.0u
MN9 n2 CKB QS vss NMOS W=3.4u L=1.0u
MN10 n2 QB vss vss NMOS W=3.4u L=1.0u
MN11 n1 QS vss vss NMOS W=3.4u L=1.0u
MN12 n1 RSTB QB vss NMOS W=3.4u L=1.0u
.ends DFFRB
