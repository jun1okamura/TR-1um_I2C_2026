* REG8x16 — LVS ソースネットリスト（設計意図）
* generated by scripts/mkspice.py   TR-1um (IP62), L = 1.0 um
*
* 注意:
*  - これはレイアウト抽出ではなく設計意図。LVS はこれと抽出結果を突き合わせる。
*  - トランジスタモデル名 pmos/nmos は PDK の LVS 設定に合わせて読み替えること
*    (TR-1um/libs.tech/klayout/tech/lvs/run.lvs)。
*  - ポート順・ポート名は GDS のピンラベルに合わせること。

* TLAT — 12T ratioless ラッチ ビットセル (37.8 x 59.4 um)
.subckt TLAT WR WRB RD RDB D Q vdd vss
MP0 D WRB n3 vdd PMOS W=7.2u L=1.0u
MN0 D WR n3 vss NMOS W=3.4u L=1.0u
MP1 n1 n3 vdd vdd PMOS W=7.2u L=1.0u
MN1 n1 n3 vss vss NMOS W=3.4u L=1.0u
MP2 n2 n1 vdd vdd PMOS W=7.2u L=1.0u
MN2 n2 n1 vss vss NMOS W=3.4u L=1.0u
MP3 n2 WR n3 vdd PMOS W=7.2u L=1.0u
MN3 n2 WRB n3 vss NMOS W=3.4u L=1.0u
MP4 n4 n1 vdd vdd PMOS W=7.2u L=1.0u
MN4 n4 n1 vss vss NMOS W=3.4u L=1.0u
MP5 n4 RDB Q vdd PMOS W=7.2u L=1.0u
MN5 n4 RD Q vss NMOS W=3.4u L=1.0u
.ends TLAT

* DEC2 — デコーダ2行ぶん (114.0 x 86.4 um, 32Tr, 16pin)
*   E = 偶数行 2k（bit0=0 → AB0）/ O = 奇数行 2k+1（bit0=1 → A0）
*   A1..A3 は2行で共有 / タップ内蔵なのでバルク = レール
.subckt DEC2 A0 AB0 A1 A2 A3 WEB WRE WRBE RDE RDBE WRO WRBO RDO RDBO vdd vss
* --- 行 E: RDB=NAND4(A) / RD=INV / WR=NOR2(RDB,WEB) / WRB=INV ---
MPE0 RDBE AB0 vdd vdd PMOS W=12.2u L=1.0u
MPE1 RDBE A1 vdd vdd PMOS W=12.2u L=1.0u
MPE2 RDBE A2 vdd vdd PMOS W=12.2u L=1.0u
MPE3 RDBE A3 vdd vdd PMOS W=12.2u L=1.0u
MNE0 s1_E A3 vss vss NMOS W=4.6u L=1.0u
MNE1 s2_E A2 s1_E vss NMOS W=4.6u L=1.0u
MNE2 s3_E A1 s2_E vss NMOS W=4.6u L=1.0u
MNE3 RDBE AB0 s3_E vss NMOS W=4.6u L=1.0u
MPEA RDE RDBE vdd vdd PMOS W=12.2u L=1.0u
MNEA RDE RDBE vss vss NMOS W=4.6u L=1.0u
MPEB p1_E WEB vdd vdd PMOS W=12.2u L=1.0u
MPEC WRE RDBE p1_E vdd PMOS W=12.2u L=1.0u
MNEB WRE RDBE vss vss NMOS W=4.6u L=1.0u
MNEC WRE WEB vss vss NMOS W=4.6u L=1.0u
MPED WRBE WRE vdd vdd PMOS W=12.2u L=1.0u
MNED WRBE WRE vss vss NMOS W=4.6u L=1.0u
* --- 行 O: RDB=NAND4(A) / RD=INV / WR=NOR2(RDB,WEB) / WRB=INV ---
MPO0 RDBO A0 vdd vdd PMOS W=12.2u L=1.0u
MPO1 RDBO A1 vdd vdd PMOS W=12.2u L=1.0u
MPO2 RDBO A2 vdd vdd PMOS W=12.2u L=1.0u
MPO3 RDBO A3 vdd vdd PMOS W=12.2u L=1.0u
MNO0 s1_O A3 vss vss NMOS W=4.6u L=1.0u
MNO1 s2_O A2 s1_O vss NMOS W=4.6u L=1.0u
MNO2 s3_O A1 s2_O vss NMOS W=4.6u L=1.0u
MNO3 RDBO A0 s3_O vss NMOS W=4.6u L=1.0u
MPOA RDO RDBO vdd vdd PMOS W=12.2u L=1.0u
MNOA RDO RDBO vss vss NMOS W=4.6u L=1.0u
MPOB p1_O WEB vdd vdd PMOS W=12.2u L=1.0u
MPOC WRO RDBO p1_O vdd PMOS W=12.2u L=1.0u
MNOB WRO RDBO vss vss NMOS W=4.6u L=1.0u
MNOC WRO WEB vss vss NMOS W=4.6u L=1.0u
MPOD WRBO WRO vdd vdd PMOS W=12.2u L=1.0u
MNOD WRBO WRO vss vss NMOS W=4.6u L=1.0u
.ends DEC2

* REGBUF — 1bit ぶんのデータバッファ (37.8 x 59.4 um)
*   D -> DD : 書込（外部 → ビット線） / Q -> QQ : 読出（ビット線 → 外部）
*   ピン名は GDS のラベルに合わせる。**D が外側、DD がビット線側。**
*   以前は逆に書いていた（DD が外側）。LVS はネット名ではなく構造で
*   照合するので通ってしまい、名前で読む側だけが食い違っていた。
.subckt REGBUF D DD Q QQ vdd vss
MP0 w1 D vdd vdd PMOS W=10.2u L=1.0u
MN0 w1 D vss vss NMOS W=3.4u L=1.0u
MP1 DD w1 vdd vdd PMOS W=10.2u L=1.0u
MN1 DD w1 vss vss NMOS W=3.4u L=1.0u
MP2 r1 Q vdd vdd PMOS W=10.2u L=1.0u
MN2 r1 Q vss vss NMOS W=3.4u L=1.0u
MP3 QQ r1 vdd vdd PMOS W=10.2u L=1.0u
MN3 QQ r1 vss vss NMOS W=3.4u L=1.0u
.ends REGBUF

* ADDBUF — アドレス相補生成 + WE バッファ (99.0 x 63.4 um)
*   ABk = INV(Ak_PIN) / Ak = INV(ABk)  -> スキューを INV 1段に固定した平衡型
.subckt ADDBUF A0_PIN A1_PIN A2_PIN A3_PIN WEB_PIN A0 AB0 A1 AB1 A2 AB2 A3 AB3 WEB vdd vss
MP0 AB0 A0_PIN vdd vdd PMOS W=10.2u L=1.0u
MN0 AB0 A0_PIN vss vss NMOS W=3.4u L=1.0u
MP1 A0 AB0 vdd vdd PMOS W=10.2u L=1.0u
MN1 A0 AB0 vss vss NMOS W=3.4u L=1.0u
MP2 AB1 A1_PIN vdd vdd PMOS W=10.2u L=1.0u
MN2 AB1 A1_PIN vss vss NMOS W=3.4u L=1.0u
MP3 A1 AB1 vdd vdd PMOS W=10.2u L=1.0u
MN3 A1 AB1 vss vss NMOS W=3.4u L=1.0u
MP4 AB2 A2_PIN vdd vdd PMOS W=10.2u L=1.0u
MN4 AB2 A2_PIN vss vss NMOS W=3.4u L=1.0u
MP5 A2 AB2 vdd vdd PMOS W=10.2u L=1.0u
MN5 A2 AB2 vss vss NMOS W=3.4u L=1.0u
MP6 AB3 A3_PIN vdd vdd PMOS W=10.2u L=1.0u
MN6 AB3 A3_PIN vss vss NMOS W=3.4u L=1.0u
MP7 A3 AB3 vdd vdd PMOS W=10.2u L=1.0u
MN7 A3 AB3 vss vss NMOS W=3.4u L=1.0u
MP8 wt WEB_PIN vdd vdd PMOS W=10.2u L=1.0u
MN8 wt WEB_PIN vss vss NMOS W=3.4u L=1.0u
MP9 WEB wt vdd vdd PMOS W=10.2u L=1.0u
MN9 WEB wt vss vss NMOS W=3.4u L=1.0u
.ends ADDBUF

* REG8x16 — 8bit x 16word レジスタファイル (399.6 x 933.0 um)
* ポート名は GDS のピンラベル実測に一致させてある
.subckt REG8x16 ADD[0] ADD[1] ADD[2] ADD[3] WEB D[0] D[1] D[2] D[3] D[4] D[5] D[6] D[7] Q[0] Q[1] Q[2] Q[3] Q[4] Q[5] Q[6] Q[7] vdd vss

* アドレス相補生成 + WE バッファ
XADDBUF ADD[0] ADD[1] ADD[2] ADD[3] WEB a0 ab0 a1 ab1 a2 ab2 a3 ab3 WEBI vdd vss ADDBUF

* 行デコーダ: DEC2 x8（1個で2行、bit0 以外のアドレスは2行で共有）
XDEC2_0 a0 ab0 ab1 ab2 ab3 WEBI wr0 wrb0 rd0 rdb0 wr1 wrb1 rd1 rdb1 vdd vss DEC2
XDEC2_1 a0 ab0 a1 ab2 ab3 WEBI wr2 wrb2 rd2 rdb2 wr3 wrb3 rd3 rdb3 vdd vss DEC2
XDEC2_2 a0 ab0 ab1 a2 ab3 WEBI wr4 wrb4 rd4 rdb4 wr5 wrb5 rd5 rdb5 vdd vss DEC2
XDEC2_3 a0 ab0 a1 a2 ab3 WEBI wr6 wrb6 rd6 rdb6 wr7 wrb7 rd7 rdb7 vdd vss DEC2
XDEC2_4 a0 ab0 ab1 ab2 a3 WEBI wr8 wrb8 rd8 rdb8 wr9 wrb9 rd9 rdb9 vdd vss DEC2
XDEC2_5 a0 ab0 a1 ab2 a3 WEBI wr10 wrb10 rd10 rdb10 wr11 wrb11 rd11 rdb11 vdd vss DEC2
XDEC2_6 a0 ab0 ab1 a2 a3 WEBI wr12 wrb12 rd12 rdb12 wr13 wrb13 rd13 rdb13 vdd vss DEC2
XDEC2_7 a0 ab0 a1 a2 a3 WEBI wr14 wrb14 rd14 rdb14 wr15 wrb15 rd15 rdb15 vdd vss DEC2

* ビットセル 16 x 8
XT00_0 wr0 wrb0 rd0 rdb0 dl0 ql0 vdd vss TLAT
XT00_1 wr0 wrb0 rd0 rdb0 dl1 ql1 vdd vss TLAT
XT00_2 wr0 wrb0 rd0 rdb0 dl2 ql2 vdd vss TLAT
XT00_3 wr0 wrb0 rd0 rdb0 dl3 ql3 vdd vss TLAT
XT00_4 wr0 wrb0 rd0 rdb0 dl4 ql4 vdd vss TLAT
XT00_5 wr0 wrb0 rd0 rdb0 dl5 ql5 vdd vss TLAT
XT00_6 wr0 wrb0 rd0 rdb0 dl6 ql6 vdd vss TLAT
XT00_7 wr0 wrb0 rd0 rdb0 dl7 ql7 vdd vss TLAT
XT01_0 wr1 wrb1 rd1 rdb1 dl0 ql0 vdd vss TLAT
XT01_1 wr1 wrb1 rd1 rdb1 dl1 ql1 vdd vss TLAT
XT01_2 wr1 wrb1 rd1 rdb1 dl2 ql2 vdd vss TLAT
XT01_3 wr1 wrb1 rd1 rdb1 dl3 ql3 vdd vss TLAT
XT01_4 wr1 wrb1 rd1 rdb1 dl4 ql4 vdd vss TLAT
XT01_5 wr1 wrb1 rd1 rdb1 dl5 ql5 vdd vss TLAT
XT01_6 wr1 wrb1 rd1 rdb1 dl6 ql6 vdd vss TLAT
XT01_7 wr1 wrb1 rd1 rdb1 dl7 ql7 vdd vss TLAT
XT02_0 wr2 wrb2 rd2 rdb2 dl0 ql0 vdd vss TLAT
XT02_1 wr2 wrb2 rd2 rdb2 dl1 ql1 vdd vss TLAT
XT02_2 wr2 wrb2 rd2 rdb2 dl2 ql2 vdd vss TLAT
XT02_3 wr2 wrb2 rd2 rdb2 dl3 ql3 vdd vss TLAT
XT02_4 wr2 wrb2 rd2 rdb2 dl4 ql4 vdd vss TLAT
XT02_5 wr2 wrb2 rd2 rdb2 dl5 ql5 vdd vss TLAT
XT02_6 wr2 wrb2 rd2 rdb2 dl6 ql6 vdd vss TLAT
XT02_7 wr2 wrb2 rd2 rdb2 dl7 ql7 vdd vss TLAT
XT03_0 wr3 wrb3 rd3 rdb3 dl0 ql0 vdd vss TLAT
XT03_1 wr3 wrb3 rd3 rdb3 dl1 ql1 vdd vss TLAT
XT03_2 wr3 wrb3 rd3 rdb3 dl2 ql2 vdd vss TLAT
XT03_3 wr3 wrb3 rd3 rdb3 dl3 ql3 vdd vss TLAT
XT03_4 wr3 wrb3 rd3 rdb3 dl4 ql4 vdd vss TLAT
XT03_5 wr3 wrb3 rd3 rdb3 dl5 ql5 vdd vss TLAT
XT03_6 wr3 wrb3 rd3 rdb3 dl6 ql6 vdd vss TLAT
XT03_7 wr3 wrb3 rd3 rdb3 dl7 ql7 vdd vss TLAT
XT04_0 wr4 wrb4 rd4 rdb4 dl0 ql0 vdd vss TLAT
XT04_1 wr4 wrb4 rd4 rdb4 dl1 ql1 vdd vss TLAT
XT04_2 wr4 wrb4 rd4 rdb4 dl2 ql2 vdd vss TLAT
XT04_3 wr4 wrb4 rd4 rdb4 dl3 ql3 vdd vss TLAT
XT04_4 wr4 wrb4 rd4 rdb4 dl4 ql4 vdd vss TLAT
XT04_5 wr4 wrb4 rd4 rdb4 dl5 ql5 vdd vss TLAT
XT04_6 wr4 wrb4 rd4 rdb4 dl6 ql6 vdd vss TLAT
XT04_7 wr4 wrb4 rd4 rdb4 dl7 ql7 vdd vss TLAT
XT05_0 wr5 wrb5 rd5 rdb5 dl0 ql0 vdd vss TLAT
XT05_1 wr5 wrb5 rd5 rdb5 dl1 ql1 vdd vss TLAT
XT05_2 wr5 wrb5 rd5 rdb5 dl2 ql2 vdd vss TLAT
XT05_3 wr5 wrb5 rd5 rdb5 dl3 ql3 vdd vss TLAT
XT05_4 wr5 wrb5 rd5 rdb5 dl4 ql4 vdd vss TLAT
XT05_5 wr5 wrb5 rd5 rdb5 dl5 ql5 vdd vss TLAT
XT05_6 wr5 wrb5 rd5 rdb5 dl6 ql6 vdd vss TLAT
XT05_7 wr5 wrb5 rd5 rdb5 dl7 ql7 vdd vss TLAT
XT06_0 wr6 wrb6 rd6 rdb6 dl0 ql0 vdd vss TLAT
XT06_1 wr6 wrb6 rd6 rdb6 dl1 ql1 vdd vss TLAT
XT06_2 wr6 wrb6 rd6 rdb6 dl2 ql2 vdd vss TLAT
XT06_3 wr6 wrb6 rd6 rdb6 dl3 ql3 vdd vss TLAT
XT06_4 wr6 wrb6 rd6 rdb6 dl4 ql4 vdd vss TLAT
XT06_5 wr6 wrb6 rd6 rdb6 dl5 ql5 vdd vss TLAT
XT06_6 wr6 wrb6 rd6 rdb6 dl6 ql6 vdd vss TLAT
XT06_7 wr6 wrb6 rd6 rdb6 dl7 ql7 vdd vss TLAT
XT07_0 wr7 wrb7 rd7 rdb7 dl0 ql0 vdd vss TLAT
XT07_1 wr7 wrb7 rd7 rdb7 dl1 ql1 vdd vss TLAT
XT07_2 wr7 wrb7 rd7 rdb7 dl2 ql2 vdd vss TLAT
XT07_3 wr7 wrb7 rd7 rdb7 dl3 ql3 vdd vss TLAT
XT07_4 wr7 wrb7 rd7 rdb7 dl4 ql4 vdd vss TLAT
XT07_5 wr7 wrb7 rd7 rdb7 dl5 ql5 vdd vss TLAT
XT07_6 wr7 wrb7 rd7 rdb7 dl6 ql6 vdd vss TLAT
XT07_7 wr7 wrb7 rd7 rdb7 dl7 ql7 vdd vss TLAT
XT08_0 wr8 wrb8 rd8 rdb8 dl0 ql0 vdd vss TLAT
XT08_1 wr8 wrb8 rd8 rdb8 dl1 ql1 vdd vss TLAT
XT08_2 wr8 wrb8 rd8 rdb8 dl2 ql2 vdd vss TLAT
XT08_3 wr8 wrb8 rd8 rdb8 dl3 ql3 vdd vss TLAT
XT08_4 wr8 wrb8 rd8 rdb8 dl4 ql4 vdd vss TLAT
XT08_5 wr8 wrb8 rd8 rdb8 dl5 ql5 vdd vss TLAT
XT08_6 wr8 wrb8 rd8 rdb8 dl6 ql6 vdd vss TLAT
XT08_7 wr8 wrb8 rd8 rdb8 dl7 ql7 vdd vss TLAT
XT09_0 wr9 wrb9 rd9 rdb9 dl0 ql0 vdd vss TLAT
XT09_1 wr9 wrb9 rd9 rdb9 dl1 ql1 vdd vss TLAT
XT09_2 wr9 wrb9 rd9 rdb9 dl2 ql2 vdd vss TLAT
XT09_3 wr9 wrb9 rd9 rdb9 dl3 ql3 vdd vss TLAT
XT09_4 wr9 wrb9 rd9 rdb9 dl4 ql4 vdd vss TLAT
XT09_5 wr9 wrb9 rd9 rdb9 dl5 ql5 vdd vss TLAT
XT09_6 wr9 wrb9 rd9 rdb9 dl6 ql6 vdd vss TLAT
XT09_7 wr9 wrb9 rd9 rdb9 dl7 ql7 vdd vss TLAT
XT10_0 wr10 wrb10 rd10 rdb10 dl0 ql0 vdd vss TLAT
XT10_1 wr10 wrb10 rd10 rdb10 dl1 ql1 vdd vss TLAT
XT10_2 wr10 wrb10 rd10 rdb10 dl2 ql2 vdd vss TLAT
XT10_3 wr10 wrb10 rd10 rdb10 dl3 ql3 vdd vss TLAT
XT10_4 wr10 wrb10 rd10 rdb10 dl4 ql4 vdd vss TLAT
XT10_5 wr10 wrb10 rd10 rdb10 dl5 ql5 vdd vss TLAT
XT10_6 wr10 wrb10 rd10 rdb10 dl6 ql6 vdd vss TLAT
XT10_7 wr10 wrb10 rd10 rdb10 dl7 ql7 vdd vss TLAT
XT11_0 wr11 wrb11 rd11 rdb11 dl0 ql0 vdd vss TLAT
XT11_1 wr11 wrb11 rd11 rdb11 dl1 ql1 vdd vss TLAT
XT11_2 wr11 wrb11 rd11 rdb11 dl2 ql2 vdd vss TLAT
XT11_3 wr11 wrb11 rd11 rdb11 dl3 ql3 vdd vss TLAT
XT11_4 wr11 wrb11 rd11 rdb11 dl4 ql4 vdd vss TLAT
XT11_5 wr11 wrb11 rd11 rdb11 dl5 ql5 vdd vss TLAT
XT11_6 wr11 wrb11 rd11 rdb11 dl6 ql6 vdd vss TLAT
XT11_7 wr11 wrb11 rd11 rdb11 dl7 ql7 vdd vss TLAT
XT12_0 wr12 wrb12 rd12 rdb12 dl0 ql0 vdd vss TLAT
XT12_1 wr12 wrb12 rd12 rdb12 dl1 ql1 vdd vss TLAT
XT12_2 wr12 wrb12 rd12 rdb12 dl2 ql2 vdd vss TLAT
XT12_3 wr12 wrb12 rd12 rdb12 dl3 ql3 vdd vss TLAT
XT12_4 wr12 wrb12 rd12 rdb12 dl4 ql4 vdd vss TLAT
XT12_5 wr12 wrb12 rd12 rdb12 dl5 ql5 vdd vss TLAT
XT12_6 wr12 wrb12 rd12 rdb12 dl6 ql6 vdd vss TLAT
XT12_7 wr12 wrb12 rd12 rdb12 dl7 ql7 vdd vss TLAT
XT13_0 wr13 wrb13 rd13 rdb13 dl0 ql0 vdd vss TLAT
XT13_1 wr13 wrb13 rd13 rdb13 dl1 ql1 vdd vss TLAT
XT13_2 wr13 wrb13 rd13 rdb13 dl2 ql2 vdd vss TLAT
XT13_3 wr13 wrb13 rd13 rdb13 dl3 ql3 vdd vss TLAT
XT13_4 wr13 wrb13 rd13 rdb13 dl4 ql4 vdd vss TLAT
XT13_5 wr13 wrb13 rd13 rdb13 dl5 ql5 vdd vss TLAT
XT13_6 wr13 wrb13 rd13 rdb13 dl6 ql6 vdd vss TLAT
XT13_7 wr13 wrb13 rd13 rdb13 dl7 ql7 vdd vss TLAT
XT14_0 wr14 wrb14 rd14 rdb14 dl0 ql0 vdd vss TLAT
XT14_1 wr14 wrb14 rd14 rdb14 dl1 ql1 vdd vss TLAT
XT14_2 wr14 wrb14 rd14 rdb14 dl2 ql2 vdd vss TLAT
XT14_3 wr14 wrb14 rd14 rdb14 dl3 ql3 vdd vss TLAT
XT14_4 wr14 wrb14 rd14 rdb14 dl4 ql4 vdd vss TLAT
XT14_5 wr14 wrb14 rd14 rdb14 dl5 ql5 vdd vss TLAT
XT14_6 wr14 wrb14 rd14 rdb14 dl6 ql6 vdd vss TLAT
XT14_7 wr14 wrb14 rd14 rdb14 dl7 ql7 vdd vss TLAT
XT15_0 wr15 wrb15 rd15 rdb15 dl0 ql0 vdd vss TLAT
XT15_1 wr15 wrb15 rd15 rdb15 dl1 ql1 vdd vss TLAT
XT15_2 wr15 wrb15 rd15 rdb15 dl2 ql2 vdd vss TLAT
XT15_3 wr15 wrb15 rd15 rdb15 dl3 ql3 vdd vss TLAT
XT15_4 wr15 wrb15 rd15 rdb15 dl4 ql4 vdd vss TLAT
XT15_5 wr15 wrb15 rd15 rdb15 dl5 ql5 vdd vss TLAT
XT15_6 wr15 wrb15 rd15 rdb15 dl6 ql6 vdd vss TLAT
XT15_7 wr15 wrb15 rd15 rdb15 dl7 ql7 vdd vss TLAT

* データバッファ x8   （トップの D[j] -> REGBUF.D、REGBUF.QQ -> トップの Q[j]）
XBUF0 D[0] dl0 ql0 Q[0] vdd vss REGBUF
XBUF1 D[1] dl1 ql1 Q[1] vdd vss REGBUF
XBUF2 D[2] dl2 ql2 Q[2] vdd vss REGBUF
XBUF3 D[3] dl3 ql3 Q[3] vdd vss REGBUF
XBUF4 D[4] dl4 ql4 Q[4] vdd vss REGBUF
XBUF5 D[5] dl5 ql5 Q[5] vdd vss REGBUF
XBUF6 D[6] dl6 ql6 Q[6] vdd vss REGBUF
XBUF7 D[7] dl7 ql7 Q[7] vdd vss REGBUF
.ends REG8x16
