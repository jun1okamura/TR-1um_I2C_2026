* INV_X2 — LVS ソースネットリスト
* scripts/char/mkcellspice.py が生成。手で編集しないこと。
*
* 出どころ: **論理式から組み立てた**（レイアウトを見ていない）。
*   Y = !A
*   CMOS の直列/並列構造は論理式から一意に決まるので、これは独立なソース。
*   レイアウト抽出とグラフ同型であることを確認済み (2Tr)。
*   -> この .spice に対する LVS が通れば「レイアウト = 意図した論理」と言える。
*
* TR-1um (IP62)  W(P)=16.2u / W(N)=6.6u / L=1.0u
*
.subckt INV_X2 A Y vdd vss
MP0 Y A vdd vdd PMOS W=16.2u L=1.0u
MN0 Y A vss vss NMOS W=6.6u L=1.0u
.ends INV_X2
