* DEL1 — LVS ソースネットリスト
* scripts/char/mkcellspice.py が生成。手で編集しないこと。
*
* 出どころ: **レイアウト抽出を golden として凍結したもの**。
*   このセルは同じ論理でも CMOS 構造が一意に決まらない（回路図が無い）。
*   10T。遅延段 4 個だけ L=2.0u にして遅らせている。
*
*   ** この .spice に対する LVS は「レイアウト vs そのレイアウトから作った網」
*      なので、今この瞬間は何も証明しない。意味があるのは
*      次にレイアウトを触ったときに差分が出ること（回帰検査）。**
*
*   凍結した時点で ngspice により機能を確認済み:
*   真理値表 436 点 / 順序 87 点 すべて PASS（scripts/char/RESULTS.txt）。
*
.subckt DEL1 Y A vdd vss
MP0 vdd n1 n2 vdd PMOS W=10.2u L=2.0u
MP1 vdd n2 Y vdd PMOS W=10.2u L=1.0u
MP2 vdd n2 Y vdd PMOS W=10.2u L=1.0u
MP3 vdd A n3 vdd PMOS W=10.2u L=1.0u
MP4 vdd n3 n1 vdd PMOS W=10.2u L=2.0u
MN0 n2 n1 vss vss NMOS W=3.4u L=2.0u
MN1 vss n2 Y vss NMOS W=3.4u L=1.0u
MN2 vss n2 Y vss NMOS W=3.4u L=1.0u
MN3 n3 A vss vss NMOS W=3.4u L=1.0u
MN4 n1 n3 vss vss NMOS W=3.4u L=2.0u
.ends DEL1
