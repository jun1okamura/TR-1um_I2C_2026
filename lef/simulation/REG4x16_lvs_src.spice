* REG4x16 — LVS ソースネットリスト（設計意図）
* generated by scripts/mkspice.py   TR-1um (IP62), L = 1.0 um
*
* 注意:
*  - これはレイアウト抽出ではなく設計意図。LVS はこれと抽出結果を突き合わせる。
*  - トランジスタモデル名 pmos/nmos は PDK の LVS 設定に合わせて読み替えること
*    (TR-1um/libs.tech/klayout/tech/lvs/run.lvs)。
*  - ポート順・ポート名は GDS のピンラベルに合わせること。

* TLAT — 12T ratioless ラッチ ビットセル (37.8 x 59.4 um)
.subckt TLAT WR WRB RD RDB D Q vdd vss
MP0 D WRB n3 vdd pmos W=7.2u L=1.0u
MN0 D WR n3 vss nmos W=3.4u L=1.0u
MP1 n1 n3 vdd vdd pmos W=7.2u L=1.0u
MN1 n1 n3 vss vss nmos W=3.4u L=1.0u
MP2 n2 n1 vdd vdd pmos W=7.2u L=1.0u
MN2 n2 n1 vss vss nmos W=3.4u L=1.0u
MP3 n2 WR n3 vdd pmos W=7.2u L=1.0u
MN3 n2 WRB n3 vss nmos W=3.4u L=1.0u
MP4 n4 n1 vdd vdd pmos W=7.2u L=1.0u
MN4 n4 n1 vss vss nmos W=3.4u L=1.0u
MP5 n4 RDB Q vdd pmos W=7.2u L=1.0u
MN5 n4 RD Q vss nmos W=3.4u L=1.0u
.ends TLAT

* DEC0 — 1行分のデコーダ + ワードラインドライバ (59.4 x 86.4 um)
.subckt DEC0 A0 A1 A2 A3 WEB WR WRB RD RDB vdd vss
* NAND4: RDB = !(A0 & A1 & A2 & A3)
MP0 RDB A0 vdd vdd pmos W=12.2u L=1.0u
MP1 RDB A1 vdd vdd pmos W=12.2u L=1.0u
MP2 RDB A2 vdd vdd pmos W=12.2u L=1.0u
MP3 RDB A3 vdd vdd pmos W=12.2u L=1.0u
MN0 s1 A0 vss vss nmos W=4.6u L=1.0u
MN1 s2 A1 s1 vss nmos W=4.6u L=1.0u
MN2 s3 A2 s2 vss nmos W=4.6u L=1.0u
MN3 RDB A3 s3 vss nmos W=4.6u L=1.0u
* INV: RD = !RDB
MP10 RD RDB vdd vdd pmos W=12.2u L=1.0u
MN10 RD RDB vss vss nmos W=4.6u L=1.0u
* NOR2: WR = !(RDB | WEB)   -> 選択行 かつ WEB=L のとき書込
MP20 p1 RDB vdd vdd pmos W=12.2u L=1.0u
MP21 WR WEB p1 vdd pmos W=12.2u L=1.0u
MN20 WR RDB vss vss nmos W=4.6u L=1.0u
MN21 WR WEB vss vss nmos W=4.6u L=1.0u
* INV: WRB = !WR
MP30 WRB WR vdd vdd pmos W=12.2u L=1.0u
MN30 WRB WR vss vss nmos W=4.6u L=1.0u
.ends DEC0

* REGBUF — 1bit ぶんのデータバッファ (37.8 x 59.4 um)
*   DD -> D : 書込（外部 → ビット線） / Q -> QQ : 読出（ビット線 → 外部）
.subckt REGBUF DD D Q QQ vdd vss
MP0 w1 DD vdd vdd pmos W=10.2u L=1.0u
MN0 w1 DD vss vss nmos W=3.4u L=1.0u
MP1 D w1 vdd vdd pmos W=10.2u L=1.0u
MN1 D w1 vss vss nmos W=3.4u L=1.0u
MP2 r1 Q vdd vdd pmos W=10.2u L=1.0u
MN2 r1 Q vss vss nmos W=3.4u L=1.0u
MP3 QQ r1 vdd vdd pmos W=10.2u L=1.0u
MN3 QQ r1 vss vss nmos W=3.4u L=1.0u
.ends REGBUF

* ADDBUF — アドレス相補生成 + WE バッファ (99.0 x 63.4 um)
*   ABk = INV(Ak_PIN) / Ak = INV(ABk)  -> スキューを INV 1段に固定した平衡型
.subckt ADDBUF A0_PIN A1_PIN A2_PIN A3_PIN WEB_PIN A0 AB0 A1 AB1 A2 AB2 A3 AB3 WEB vdd vss
MP0 AB0 A0_PIN vdd vdd pmos W=10.2u L=1.0u
MN0 AB0 A0_PIN vss vss nmos W=3.4u L=1.0u
MP1 A0 AB0 vdd vdd pmos W=10.2u L=1.0u
MN1 A0 AB0 vss vss nmos W=3.4u L=1.0u
MP2 AB1 A1_PIN vdd vdd pmos W=10.2u L=1.0u
MN2 AB1 A1_PIN vss vss nmos W=3.4u L=1.0u
MP3 A1 AB1 vdd vdd pmos W=10.2u L=1.0u
MN3 A1 AB1 vss vss nmos W=3.4u L=1.0u
MP4 AB2 A2_PIN vdd vdd pmos W=10.2u L=1.0u
MN4 AB2 A2_PIN vss vss nmos W=3.4u L=1.0u
MP5 A2 AB2 vdd vdd pmos W=10.2u L=1.0u
MN5 A2 AB2 vss vss nmos W=3.4u L=1.0u
MP6 AB3 A3_PIN vdd vdd pmos W=10.2u L=1.0u
MN6 AB3 A3_PIN vss vss nmos W=3.4u L=1.0u
MP7 A3 AB3 vdd vdd pmos W=10.2u L=1.0u
MN7 A3 AB3 vss vss nmos W=3.4u L=1.0u
MP8 wt WEB_PIN vdd vdd pmos W=10.2u L=1.0u
MN8 wt WEB_PIN vss vss nmos W=3.4u L=1.0u
MP9 WEB wt vdd vdd pmos W=10.2u L=1.0u
MN9 WEB wt vss vss nmos W=3.4u L=1.0u
.ends ADDBUF

* REG4x16 — 4bit x 16word レジスタファイル (248.4 x 933.0 um)
* ポート名は GDS のピンラベル実測に一致させてある
.subckt REG4x16 ADD[0] ADD[1] ADD[2] ADD[3] WEB D[0] D[1] D[2] D[3] Q[0] Q[1] Q[2] Q[3] vdd vss

* アドレス相補生成 + WE バッファ
XADDBUF ADD[0] ADD[1] ADD[2] ADD[3] WEB a0 ab0 a1 ab1 a2 ab2 a3 ab3 web vdd vss ADDBUF

* 行デコーダ + ワードラインドライバ x16
XDEC00 ab0 ab1 ab2 ab3 web wr0 wrb0 rd0 rdb0 vdd vss DEC0
XDEC01 a0 ab1 ab2 ab3 web wr1 wrb1 rd1 rdb1 vdd vss DEC0
XDEC02 ab0 a1 ab2 ab3 web wr2 wrb2 rd2 rdb2 vdd vss DEC0
XDEC03 a0 a1 ab2 ab3 web wr3 wrb3 rd3 rdb3 vdd vss DEC0
XDEC04 ab0 ab1 a2 ab3 web wr4 wrb4 rd4 rdb4 vdd vss DEC0
XDEC05 a0 ab1 a2 ab3 web wr5 wrb5 rd5 rdb5 vdd vss DEC0
XDEC06 ab0 a1 a2 ab3 web wr6 wrb6 rd6 rdb6 vdd vss DEC0
XDEC07 a0 a1 a2 ab3 web wr7 wrb7 rd7 rdb7 vdd vss DEC0
XDEC08 ab0 ab1 ab2 a3 web wr8 wrb8 rd8 rdb8 vdd vss DEC0
XDEC09 a0 ab1 ab2 a3 web wr9 wrb9 rd9 rdb9 vdd vss DEC0
XDEC10 ab0 a1 ab2 a3 web wr10 wrb10 rd10 rdb10 vdd vss DEC0
XDEC11 a0 a1 ab2 a3 web wr11 wrb11 rd11 rdb11 vdd vss DEC0
XDEC12 ab0 ab1 a2 a3 web wr12 wrb12 rd12 rdb12 vdd vss DEC0
XDEC13 a0 ab1 a2 a3 web wr13 wrb13 rd13 rdb13 vdd vss DEC0
XDEC14 ab0 a1 a2 a3 web wr14 wrb14 rd14 rdb14 vdd vss DEC0
XDEC15 a0 a1 a2 a3 web wr15 wrb15 rd15 rdb15 vdd vss DEC0

* ビットセル 16 x 4
XT00_0 wr0 wrb0 rd0 rdb0 dl0 ql0 vdd vss TLAT
XT00_1 wr0 wrb0 rd0 rdb0 dl1 ql1 vdd vss TLAT
XT00_2 wr0 wrb0 rd0 rdb0 dl2 ql2 vdd vss TLAT
XT00_3 wr0 wrb0 rd0 rdb0 dl3 ql3 vdd vss TLAT
XT01_0 wr1 wrb1 rd1 rdb1 dl0 ql0 vdd vss TLAT
XT01_1 wr1 wrb1 rd1 rdb1 dl1 ql1 vdd vss TLAT
XT01_2 wr1 wrb1 rd1 rdb1 dl2 ql2 vdd vss TLAT
XT01_3 wr1 wrb1 rd1 rdb1 dl3 ql3 vdd vss TLAT
XT02_0 wr2 wrb2 rd2 rdb2 dl0 ql0 vdd vss TLAT
XT02_1 wr2 wrb2 rd2 rdb2 dl1 ql1 vdd vss TLAT
XT02_2 wr2 wrb2 rd2 rdb2 dl2 ql2 vdd vss TLAT
XT02_3 wr2 wrb2 rd2 rdb2 dl3 ql3 vdd vss TLAT
XT03_0 wr3 wrb3 rd3 rdb3 dl0 ql0 vdd vss TLAT
XT03_1 wr3 wrb3 rd3 rdb3 dl1 ql1 vdd vss TLAT
XT03_2 wr3 wrb3 rd3 rdb3 dl2 ql2 vdd vss TLAT
XT03_3 wr3 wrb3 rd3 rdb3 dl3 ql3 vdd vss TLAT
XT04_0 wr4 wrb4 rd4 rdb4 dl0 ql0 vdd vss TLAT
XT04_1 wr4 wrb4 rd4 rdb4 dl1 ql1 vdd vss TLAT
XT04_2 wr4 wrb4 rd4 rdb4 dl2 ql2 vdd vss TLAT
XT04_3 wr4 wrb4 rd4 rdb4 dl3 ql3 vdd vss TLAT
XT05_0 wr5 wrb5 rd5 rdb5 dl0 ql0 vdd vss TLAT
XT05_1 wr5 wrb5 rd5 rdb5 dl1 ql1 vdd vss TLAT
XT05_2 wr5 wrb5 rd5 rdb5 dl2 ql2 vdd vss TLAT
XT05_3 wr5 wrb5 rd5 rdb5 dl3 ql3 vdd vss TLAT
XT06_0 wr6 wrb6 rd6 rdb6 dl0 ql0 vdd vss TLAT
XT06_1 wr6 wrb6 rd6 rdb6 dl1 ql1 vdd vss TLAT
XT06_2 wr6 wrb6 rd6 rdb6 dl2 ql2 vdd vss TLAT
XT06_3 wr6 wrb6 rd6 rdb6 dl3 ql3 vdd vss TLAT
XT07_0 wr7 wrb7 rd7 rdb7 dl0 ql0 vdd vss TLAT
XT07_1 wr7 wrb7 rd7 rdb7 dl1 ql1 vdd vss TLAT
XT07_2 wr7 wrb7 rd7 rdb7 dl2 ql2 vdd vss TLAT
XT07_3 wr7 wrb7 rd7 rdb7 dl3 ql3 vdd vss TLAT
XT08_0 wr8 wrb8 rd8 rdb8 dl0 ql0 vdd vss TLAT
XT08_1 wr8 wrb8 rd8 rdb8 dl1 ql1 vdd vss TLAT
XT08_2 wr8 wrb8 rd8 rdb8 dl2 ql2 vdd vss TLAT
XT08_3 wr8 wrb8 rd8 rdb8 dl3 ql3 vdd vss TLAT
XT09_0 wr9 wrb9 rd9 rdb9 dl0 ql0 vdd vss TLAT
XT09_1 wr9 wrb9 rd9 rdb9 dl1 ql1 vdd vss TLAT
XT09_2 wr9 wrb9 rd9 rdb9 dl2 ql2 vdd vss TLAT
XT09_3 wr9 wrb9 rd9 rdb9 dl3 ql3 vdd vss TLAT
XT10_0 wr10 wrb10 rd10 rdb10 dl0 ql0 vdd vss TLAT
XT10_1 wr10 wrb10 rd10 rdb10 dl1 ql1 vdd vss TLAT
XT10_2 wr10 wrb10 rd10 rdb10 dl2 ql2 vdd vss TLAT
XT10_3 wr10 wrb10 rd10 rdb10 dl3 ql3 vdd vss TLAT
XT11_0 wr11 wrb11 rd11 rdb11 dl0 ql0 vdd vss TLAT
XT11_1 wr11 wrb11 rd11 rdb11 dl1 ql1 vdd vss TLAT
XT11_2 wr11 wrb11 rd11 rdb11 dl2 ql2 vdd vss TLAT
XT11_3 wr11 wrb11 rd11 rdb11 dl3 ql3 vdd vss TLAT
XT12_0 wr12 wrb12 rd12 rdb12 dl0 ql0 vdd vss TLAT
XT12_1 wr12 wrb12 rd12 rdb12 dl1 ql1 vdd vss TLAT
XT12_2 wr12 wrb12 rd12 rdb12 dl2 ql2 vdd vss TLAT
XT12_3 wr12 wrb12 rd12 rdb12 dl3 ql3 vdd vss TLAT
XT13_0 wr13 wrb13 rd13 rdb13 dl0 ql0 vdd vss TLAT
XT13_1 wr13 wrb13 rd13 rdb13 dl1 ql1 vdd vss TLAT
XT13_2 wr13 wrb13 rd13 rdb13 dl2 ql2 vdd vss TLAT
XT13_3 wr13 wrb13 rd13 rdb13 dl3 ql3 vdd vss TLAT
XT14_0 wr14 wrb14 rd14 rdb14 dl0 ql0 vdd vss TLAT
XT14_1 wr14 wrb14 rd14 rdb14 dl1 ql1 vdd vss TLAT
XT14_2 wr14 wrb14 rd14 rdb14 dl2 ql2 vdd vss TLAT
XT14_3 wr14 wrb14 rd14 rdb14 dl3 ql3 vdd vss TLAT
XT15_0 wr15 wrb15 rd15 rdb15 dl0 ql0 vdd vss TLAT
XT15_1 wr15 wrb15 rd15 rdb15 dl1 ql1 vdd vss TLAT
XT15_2 wr15 wrb15 rd15 rdb15 dl2 ql2 vdd vss TLAT
XT15_3 wr15 wrb15 rd15 rdb15 dl3 ql3 vdd vss TLAT

* データバッファ x4   （トップの D[j] -> REGBUF.DD、REGBUF.QQ -> トップの Q[j]）
XBUF0 D[0] dl0 ql0 Q[0] vdd vss REGBUF
XBUF1 D[1] dl1 ql1 Q[1] vdd vss REGBUF
XBUF2 D[2] dl2 ql2 Q[2] vdd vss REGBUF
XBUF3 D[3] dl3 ql3 Q[3] vdd vss REGBUF
.ends REG4x16
