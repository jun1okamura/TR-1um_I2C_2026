* OR3 — LVS ソースネットリスト
* scripts/char/mkcellspice.py が生成。手で編集しないこと。
*
* 出どころ: **論理式から組み立てた**（レイアウトを見ていない）。
*   Y = A+B+C
*   CMOS の直列/並列構造は論理式から一意に決まるので、これは独立なソース。
*   レイアウト抽出とグラフ同型であることを確認済み (8Tr)。
*   -> この .spice に対する LVS が通れば「レイアウト = 意図した論理」と言える。
*
* TR-1um (IP62)  W(P)=10.2u / W(N)=3.4u / L=1.0u
*
.subckt OR3 Y C A B vdd vss
MP0 s1 C vdd vdd PMOS W=10.2u L=1.0u
MP1 s2 B s1 vdd PMOS W=10.2u L=1.0u
MP2 n0 A s2 vdd PMOS W=10.2u L=1.0u
MN0 n0 C vss vss NMOS W=3.4u L=1.0u
MN1 n0 B vss vss NMOS W=3.4u L=1.0u
MN2 n0 A vss vss NMOS W=3.4u L=1.0u
MP3 Y n0 vdd vdd PMOS W=10.2u L=1.0u
MN3 Y n0 vss vss NMOS W=3.4u L=1.0u
.ends OR3
